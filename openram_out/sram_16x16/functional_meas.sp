.meas tran vdout0_0ck40 FIND v(dout0_0) AT=50.05n

.meas tran vdout0_1ck40 FIND v(dout0_1) AT=50.05n

.meas tran vdout0_2ck40 FIND v(dout0_2) AT=50.05n

.meas tran vdout0_3ck40 FIND v(dout0_3) AT=50.05n

.meas tran vdout0_4ck40 FIND v(dout0_4) AT=50.05n

.meas tran vdout0_5ck40 FIND v(dout0_5) AT=50.05n

.meas tran vdout0_6ck40 FIND v(dout0_6) AT=50.05n

.meas tran vdout0_7ck40 FIND v(dout0_7) AT=50.05n

.meas tran vdout0_8ck40 FIND v(dout0_8) AT=50.05n

.meas tran vdout0_9ck40 FIND v(dout0_9) AT=50.05n

.meas tran vdout0_10ck40 FIND v(dout0_10) AT=50.05n

.meas tran vdout0_11ck40 FIND v(dout0_11) AT=50.05n

.meas tran vdout0_12ck40 FIND v(dout0_12) AT=50.05n

.meas tran vdout0_13ck40 FIND v(dout0_13) AT=50.05n

.meas tran vdout0_14ck40 FIND v(dout0_14) AT=50.05n

.meas tran vdout0_15ck40 FIND v(dout0_15) AT=50.05n

.meas tran vdout0_0ck50 FIND v(dout0_0) AT=60.05n

.meas tran vdout0_1ck50 FIND v(dout0_1) AT=60.05n

.meas tran vdout0_2ck50 FIND v(dout0_2) AT=60.05n

.meas tran vdout0_3ck50 FIND v(dout0_3) AT=60.05n

.meas tran vdout0_4ck50 FIND v(dout0_4) AT=60.05n

.meas tran vdout0_5ck50 FIND v(dout0_5) AT=60.05n

.meas tran vdout0_6ck50 FIND v(dout0_6) AT=60.05n

.meas tran vdout0_7ck50 FIND v(dout0_7) AT=60.05n

.meas tran vdout0_8ck50 FIND v(dout0_8) AT=60.05n

.meas tran vdout0_9ck50 FIND v(dout0_9) AT=60.05n

.meas tran vdout0_10ck50 FIND v(dout0_10) AT=60.05n

.meas tran vdout0_11ck50 FIND v(dout0_11) AT=60.05n

.meas tran vdout0_12ck50 FIND v(dout0_12) AT=60.05n

.meas tran vdout0_13ck50 FIND v(dout0_13) AT=60.05n

.meas tran vdout0_14ck50 FIND v(dout0_14) AT=60.05n

.meas tran vdout0_15ck50 FIND v(dout0_15) AT=60.05n

.meas tran vdout0_0ck60 FIND v(dout0_0) AT=70.05n

.meas tran vdout0_1ck60 FIND v(dout0_1) AT=70.05n

.meas tran vdout0_2ck60 FIND v(dout0_2) AT=70.05n

.meas tran vdout0_3ck60 FIND v(dout0_3) AT=70.05n

.meas tran vdout0_4ck60 FIND v(dout0_4) AT=70.05n

.meas tran vdout0_5ck60 FIND v(dout0_5) AT=70.05n

.meas tran vdout0_6ck60 FIND v(dout0_6) AT=70.05n

.meas tran vdout0_7ck60 FIND v(dout0_7) AT=70.05n

.meas tran vdout0_8ck60 FIND v(dout0_8) AT=70.05n

.meas tran vdout0_9ck60 FIND v(dout0_9) AT=70.05n

.meas tran vdout0_10ck60 FIND v(dout0_10) AT=70.05n

.meas tran vdout0_11ck60 FIND v(dout0_11) AT=70.05n

.meas tran vdout0_12ck60 FIND v(dout0_12) AT=70.05n

.meas tran vdout0_13ck60 FIND v(dout0_13) AT=70.05n

.meas tran vdout0_14ck60 FIND v(dout0_14) AT=70.05n

.meas tran vdout0_15ck60 FIND v(dout0_15) AT=70.05n

.meas tran vdout0_0ck70 FIND v(dout0_0) AT=80.05n

.meas tran vdout0_1ck70 FIND v(dout0_1) AT=80.05n

.meas tran vdout0_2ck70 FIND v(dout0_2) AT=80.05n

.meas tran vdout0_3ck70 FIND v(dout0_3) AT=80.05n

.meas tran vdout0_4ck70 FIND v(dout0_4) AT=80.05n

.meas tran vdout0_5ck70 FIND v(dout0_5) AT=80.05n

.meas tran vdout0_6ck70 FIND v(dout0_6) AT=80.05n

.meas tran vdout0_7ck70 FIND v(dout0_7) AT=80.05n

.meas tran vdout0_8ck70 FIND v(dout0_8) AT=80.05n

.meas tran vdout0_9ck70 FIND v(dout0_9) AT=80.05n

.meas tran vdout0_10ck70 FIND v(dout0_10) AT=80.05n

.meas tran vdout0_11ck70 FIND v(dout0_11) AT=80.05n

.meas tran vdout0_12ck70 FIND v(dout0_12) AT=80.05n

.meas tran vdout0_13ck70 FIND v(dout0_13) AT=80.05n

.meas tran vdout0_14ck70 FIND v(dout0_14) AT=80.05n

.meas tran vdout0_15ck70 FIND v(dout0_15) AT=80.05n

.meas tran vdout0_0ck100 FIND v(dout0_0) AT=110.05n

.meas tran vdout0_1ck100 FIND v(dout0_1) AT=110.05n

.meas tran vdout0_2ck100 FIND v(dout0_2) AT=110.05n

.meas tran vdout0_3ck100 FIND v(dout0_3) AT=110.05n

.meas tran vdout0_4ck100 FIND v(dout0_4) AT=110.05n

.meas tran vdout0_5ck100 FIND v(dout0_5) AT=110.05n

.meas tran vdout0_6ck100 FIND v(dout0_6) AT=110.05n

.meas tran vdout0_7ck100 FIND v(dout0_7) AT=110.05n

.meas tran vdout0_8ck100 FIND v(dout0_8) AT=110.05n

.meas tran vdout0_9ck100 FIND v(dout0_9) AT=110.05n

.meas tran vdout0_10ck100 FIND v(dout0_10) AT=110.05n

.meas tran vdout0_11ck100 FIND v(dout0_11) AT=110.05n

.meas tran vdout0_12ck100 FIND v(dout0_12) AT=110.05n

.meas tran vdout0_13ck100 FIND v(dout0_13) AT=110.05n

.meas tran vdout0_14ck100 FIND v(dout0_14) AT=110.05n

.meas tran vdout0_15ck100 FIND v(dout0_15) AT=110.05n

.meas tran vdout0_0ck190 FIND v(dout0_0) AT=200.05n

.meas tran vdout0_1ck190 FIND v(dout0_1) AT=200.05n

.meas tran vdout0_2ck190 FIND v(dout0_2) AT=200.05n

.meas tran vdout0_3ck190 FIND v(dout0_3) AT=200.05n

.meas tran vdout0_4ck190 FIND v(dout0_4) AT=200.05n

.meas tran vdout0_5ck190 FIND v(dout0_5) AT=200.05n

.meas tran vdout0_6ck190 FIND v(dout0_6) AT=200.05n

.meas tran vdout0_7ck190 FIND v(dout0_7) AT=200.05n

.meas tran vdout0_8ck190 FIND v(dout0_8) AT=200.05n

.meas tran vdout0_9ck190 FIND v(dout0_9) AT=200.05n

.meas tran vdout0_10ck190 FIND v(dout0_10) AT=200.05n

.meas tran vdout0_11ck190 FIND v(dout0_11) AT=200.05n

.meas tran vdout0_12ck190 FIND v(dout0_12) AT=200.05n

.meas tran vdout0_13ck190 FIND v(dout0_13) AT=200.05n

.meas tran vdout0_14ck190 FIND v(dout0_14) AT=200.05n

.meas tran vdout0_15ck190 FIND v(dout0_15) AT=200.05n

.meas tran vdout0_0ck200 FIND v(dout0_0) AT=210.05n

.meas tran vdout0_1ck200 FIND v(dout0_1) AT=210.05n

.meas tran vdout0_2ck200 FIND v(dout0_2) AT=210.05n

.meas tran vdout0_3ck200 FIND v(dout0_3) AT=210.05n

.meas tran vdout0_4ck200 FIND v(dout0_4) AT=210.05n

.meas tran vdout0_5ck200 FIND v(dout0_5) AT=210.05n

.meas tran vdout0_6ck200 FIND v(dout0_6) AT=210.05n

.meas tran vdout0_7ck200 FIND v(dout0_7) AT=210.05n

.meas tran vdout0_8ck200 FIND v(dout0_8) AT=210.05n

.meas tran vdout0_9ck200 FIND v(dout0_9) AT=210.05n

.meas tran vdout0_10ck200 FIND v(dout0_10) AT=210.05n

.meas tran vdout0_11ck200 FIND v(dout0_11) AT=210.05n

.meas tran vdout0_12ck200 FIND v(dout0_12) AT=210.05n

.meas tran vdout0_13ck200 FIND v(dout0_13) AT=210.05n

.meas tran vdout0_14ck200 FIND v(dout0_14) AT=210.05n

.meas tran vdout0_15ck200 FIND v(dout0_15) AT=210.05n

.meas tran vdout0_0ck210 FIND v(dout0_0) AT=220.05n

.meas tran vdout0_1ck210 FIND v(dout0_1) AT=220.05n

.meas tran vdout0_2ck210 FIND v(dout0_2) AT=220.05n

.meas tran vdout0_3ck210 FIND v(dout0_3) AT=220.05n

.meas tran vdout0_4ck210 FIND v(dout0_4) AT=220.05n

.meas tran vdout0_5ck210 FIND v(dout0_5) AT=220.05n

.meas tran vdout0_6ck210 FIND v(dout0_6) AT=220.05n

.meas tran vdout0_7ck210 FIND v(dout0_7) AT=220.05n

.meas tran vdout0_8ck210 FIND v(dout0_8) AT=220.05n

.meas tran vdout0_9ck210 FIND v(dout0_9) AT=220.05n

.meas tran vdout0_10ck210 FIND v(dout0_10) AT=220.05n

.meas tran vdout0_11ck210 FIND v(dout0_11) AT=220.05n

.meas tran vdout0_12ck210 FIND v(dout0_12) AT=220.05n

.meas tran vdout0_13ck210 FIND v(dout0_13) AT=220.05n

.meas tran vdout0_14ck210 FIND v(dout0_14) AT=220.05n

.meas tran vdout0_15ck210 FIND v(dout0_15) AT=220.05n

.meas tran vdout0_0ck230 FIND v(dout0_0) AT=240.05n

.meas tran vdout0_1ck230 FIND v(dout0_1) AT=240.05n

.meas tran vdout0_2ck230 FIND v(dout0_2) AT=240.05n

.meas tran vdout0_3ck230 FIND v(dout0_3) AT=240.05n

.meas tran vdout0_4ck230 FIND v(dout0_4) AT=240.05n

.meas tran vdout0_5ck230 FIND v(dout0_5) AT=240.05n

.meas tran vdout0_6ck230 FIND v(dout0_6) AT=240.05n

.meas tran vdout0_7ck230 FIND v(dout0_7) AT=240.05n

.meas tran vdout0_8ck230 FIND v(dout0_8) AT=240.05n

.meas tran vdout0_9ck230 FIND v(dout0_9) AT=240.05n

.meas tran vdout0_10ck230 FIND v(dout0_10) AT=240.05n

.meas tran vdout0_11ck230 FIND v(dout0_11) AT=240.05n

.meas tran vdout0_12ck230 FIND v(dout0_12) AT=240.05n

.meas tran vdout0_13ck230 FIND v(dout0_13) AT=240.05n

.meas tran vdout0_14ck230 FIND v(dout0_14) AT=240.05n

.meas tran vdout0_15ck230 FIND v(dout0_15) AT=240.05n

.meas tran vdout0_0ck250 FIND v(dout0_0) AT=260.05n

.meas tran vdout0_1ck250 FIND v(dout0_1) AT=260.05n

.meas tran vdout0_2ck250 FIND v(dout0_2) AT=260.05n

.meas tran vdout0_3ck250 FIND v(dout0_3) AT=260.05n

.meas tran vdout0_4ck250 FIND v(dout0_4) AT=260.05n

.meas tran vdout0_5ck250 FIND v(dout0_5) AT=260.05n

.meas tran vdout0_6ck250 FIND v(dout0_6) AT=260.05n

.meas tran vdout0_7ck250 FIND v(dout0_7) AT=260.05n

.meas tran vdout0_8ck250 FIND v(dout0_8) AT=260.05n

.meas tran vdout0_9ck250 FIND v(dout0_9) AT=260.05n

.meas tran vdout0_10ck250 FIND v(dout0_10) AT=260.05n

.meas tran vdout0_11ck250 FIND v(dout0_11) AT=260.05n

.meas tran vdout0_12ck250 FIND v(dout0_12) AT=260.05n

.meas tran vdout0_13ck250 FIND v(dout0_13) AT=260.05n

.meas tran vdout0_14ck250 FIND v(dout0_14) AT=260.05n

.meas tran vdout0_15ck250 FIND v(dout0_15) AT=260.05n

.meas tran vdout0_0ck260 FIND v(dout0_0) AT=270.05n

.meas tran vdout0_1ck260 FIND v(dout0_1) AT=270.05n

.meas tran vdout0_2ck260 FIND v(dout0_2) AT=270.05n

.meas tran vdout0_3ck260 FIND v(dout0_3) AT=270.05n

.meas tran vdout0_4ck260 FIND v(dout0_4) AT=270.05n

.meas tran vdout0_5ck260 FIND v(dout0_5) AT=270.05n

.meas tran vdout0_6ck260 FIND v(dout0_6) AT=270.05n

.meas tran vdout0_7ck260 FIND v(dout0_7) AT=270.05n

.meas tran vdout0_8ck260 FIND v(dout0_8) AT=270.05n

.meas tran vdout0_9ck260 FIND v(dout0_9) AT=270.05n

.meas tran vdout0_10ck260 FIND v(dout0_10) AT=270.05n

.meas tran vdout0_11ck260 FIND v(dout0_11) AT=270.05n

.meas tran vdout0_12ck260 FIND v(dout0_12) AT=270.05n

.meas tran vdout0_13ck260 FIND v(dout0_13) AT=270.05n

.meas tran vdout0_14ck260 FIND v(dout0_14) AT=270.05n

.meas tran vdout0_15ck260 FIND v(dout0_15) AT=270.05n

.meas tran vdout0_0ck270 FIND v(dout0_0) AT=280.05n

.meas tran vdout0_1ck270 FIND v(dout0_1) AT=280.05n

.meas tran vdout0_2ck270 FIND v(dout0_2) AT=280.05n

.meas tran vdout0_3ck270 FIND v(dout0_3) AT=280.05n

.meas tran vdout0_4ck270 FIND v(dout0_4) AT=280.05n

.meas tran vdout0_5ck270 FIND v(dout0_5) AT=280.05n

.meas tran vdout0_6ck270 FIND v(dout0_6) AT=280.05n

.meas tran vdout0_7ck270 FIND v(dout0_7) AT=280.05n

.meas tran vdout0_8ck270 FIND v(dout0_8) AT=280.05n

.meas tran vdout0_9ck270 FIND v(dout0_9) AT=280.05n

.meas tran vdout0_10ck270 FIND v(dout0_10) AT=280.05n

.meas tran vdout0_11ck270 FIND v(dout0_11) AT=280.05n

.meas tran vdout0_12ck270 FIND v(dout0_12) AT=280.05n

.meas tran vdout0_13ck270 FIND v(dout0_13) AT=280.05n

.meas tran vdout0_14ck270 FIND v(dout0_14) AT=280.05n

.meas tran vdout0_15ck270 FIND v(dout0_15) AT=280.05n

.meas tran vdout0_0ck280 FIND v(dout0_0) AT=290.05n

.meas tran vdout0_1ck280 FIND v(dout0_1) AT=290.05n

.meas tran vdout0_2ck280 FIND v(dout0_2) AT=290.05n

.meas tran vdout0_3ck280 FIND v(dout0_3) AT=290.05n

.meas tran vdout0_4ck280 FIND v(dout0_4) AT=290.05n

.meas tran vdout0_5ck280 FIND v(dout0_5) AT=290.05n

.meas tran vdout0_6ck280 FIND v(dout0_6) AT=290.05n

.meas tran vdout0_7ck280 FIND v(dout0_7) AT=290.05n

.meas tran vdout0_8ck280 FIND v(dout0_8) AT=290.05n

.meas tran vdout0_9ck280 FIND v(dout0_9) AT=290.05n

.meas tran vdout0_10ck280 FIND v(dout0_10) AT=290.05n

.meas tran vdout0_11ck280 FIND v(dout0_11) AT=290.05n

.meas tran vdout0_12ck280 FIND v(dout0_12) AT=290.05n

.meas tran vdout0_13ck280 FIND v(dout0_13) AT=290.05n

.meas tran vdout0_14ck280 FIND v(dout0_14) AT=290.05n

.meas tran vdout0_15ck280 FIND v(dout0_15) AT=290.05n

.meas tran vdout0_0ck310 FIND v(dout0_0) AT=320.05n

.meas tran vdout0_1ck310 FIND v(dout0_1) AT=320.05n

.meas tran vdout0_2ck310 FIND v(dout0_2) AT=320.05n

.meas tran vdout0_3ck310 FIND v(dout0_3) AT=320.05n

.meas tran vdout0_4ck310 FIND v(dout0_4) AT=320.05n

.meas tran vdout0_5ck310 FIND v(dout0_5) AT=320.05n

.meas tran vdout0_6ck310 FIND v(dout0_6) AT=320.05n

.meas tran vdout0_7ck310 FIND v(dout0_7) AT=320.05n

.meas tran vdout0_8ck310 FIND v(dout0_8) AT=320.05n

.meas tran vdout0_9ck310 FIND v(dout0_9) AT=320.05n

.meas tran vdout0_10ck310 FIND v(dout0_10) AT=320.05n

.meas tran vdout0_11ck310 FIND v(dout0_11) AT=320.05n

.meas tran vdout0_12ck310 FIND v(dout0_12) AT=320.05n

.meas tran vdout0_13ck310 FIND v(dout0_13) AT=320.05n

.meas tran vdout0_14ck310 FIND v(dout0_14) AT=320.05n

.meas tran vdout0_15ck310 FIND v(dout0_15) AT=320.05n

.meas tran vdout0_0ck320 FIND v(dout0_0) AT=330.05n

.meas tran vdout0_1ck320 FIND v(dout0_1) AT=330.05n

.meas tran vdout0_2ck320 FIND v(dout0_2) AT=330.05n

.meas tran vdout0_3ck320 FIND v(dout0_3) AT=330.05n

.meas tran vdout0_4ck320 FIND v(dout0_4) AT=330.05n

.meas tran vdout0_5ck320 FIND v(dout0_5) AT=330.05n

.meas tran vdout0_6ck320 FIND v(dout0_6) AT=330.05n

.meas tran vdout0_7ck320 FIND v(dout0_7) AT=330.05n

.meas tran vdout0_8ck320 FIND v(dout0_8) AT=330.05n

.meas tran vdout0_9ck320 FIND v(dout0_9) AT=330.05n

.meas tran vdout0_10ck320 FIND v(dout0_10) AT=330.05n

.meas tran vdout0_11ck320 FIND v(dout0_11) AT=330.05n

.meas tran vdout0_12ck320 FIND v(dout0_12) AT=330.05n

.meas tran vdout0_13ck320 FIND v(dout0_13) AT=330.05n

.meas tran vdout0_14ck320 FIND v(dout0_14) AT=330.05n

.meas tran vdout0_15ck320 FIND v(dout0_15) AT=330.05n

.meas tran vdout0_0ck370 FIND v(dout0_0) AT=380.05n

.meas tran vdout0_1ck370 FIND v(dout0_1) AT=380.05n

.meas tran vdout0_2ck370 FIND v(dout0_2) AT=380.05n

.meas tran vdout0_3ck370 FIND v(dout0_3) AT=380.05n

.meas tran vdout0_4ck370 FIND v(dout0_4) AT=380.05n

.meas tran vdout0_5ck370 FIND v(dout0_5) AT=380.05n

.meas tran vdout0_6ck370 FIND v(dout0_6) AT=380.05n

.meas tran vdout0_7ck370 FIND v(dout0_7) AT=380.05n

.meas tran vdout0_8ck370 FIND v(dout0_8) AT=380.05n

.meas tran vdout0_9ck370 FIND v(dout0_9) AT=380.05n

.meas tran vdout0_10ck370 FIND v(dout0_10) AT=380.05n

.meas tran vdout0_11ck370 FIND v(dout0_11) AT=380.05n

.meas tran vdout0_12ck370 FIND v(dout0_12) AT=380.05n

.meas tran vdout0_13ck370 FIND v(dout0_13) AT=380.05n

.meas tran vdout0_14ck370 FIND v(dout0_14) AT=380.05n

.meas tran vdout0_15ck370 FIND v(dout0_15) AT=380.05n

.meas tran vdout0_0ck390 FIND v(dout0_0) AT=400.05n

.meas tran vdout0_1ck390 FIND v(dout0_1) AT=400.05n

.meas tran vdout0_2ck390 FIND v(dout0_2) AT=400.05n

.meas tran vdout0_3ck390 FIND v(dout0_3) AT=400.05n

.meas tran vdout0_4ck390 FIND v(dout0_4) AT=400.05n

.meas tran vdout0_5ck390 FIND v(dout0_5) AT=400.05n

.meas tran vdout0_6ck390 FIND v(dout0_6) AT=400.05n

.meas tran vdout0_7ck390 FIND v(dout0_7) AT=400.05n

.meas tran vdout0_8ck390 FIND v(dout0_8) AT=400.05n

.meas tran vdout0_9ck390 FIND v(dout0_9) AT=400.05n

.meas tran vdout0_10ck390 FIND v(dout0_10) AT=400.05n

.meas tran vdout0_11ck390 FIND v(dout0_11) AT=400.05n

.meas tran vdout0_12ck390 FIND v(dout0_12) AT=400.05n

.meas tran vdout0_13ck390 FIND v(dout0_13) AT=400.05n

.meas tran vdout0_14ck390 FIND v(dout0_14) AT=400.05n

.meas tran vdout0_15ck390 FIND v(dout0_15) AT=400.05n

.meas tran vdout0_0ck410 FIND v(dout0_0) AT=420.05n

.meas tran vdout0_1ck410 FIND v(dout0_1) AT=420.05n

.meas tran vdout0_2ck410 FIND v(dout0_2) AT=420.05n

.meas tran vdout0_3ck410 FIND v(dout0_3) AT=420.05n

.meas tran vdout0_4ck410 FIND v(dout0_4) AT=420.05n

.meas tran vdout0_5ck410 FIND v(dout0_5) AT=420.05n

.meas tran vdout0_6ck410 FIND v(dout0_6) AT=420.05n

.meas tran vdout0_7ck410 FIND v(dout0_7) AT=420.05n

.meas tran vdout0_8ck410 FIND v(dout0_8) AT=420.05n

.meas tran vdout0_9ck410 FIND v(dout0_9) AT=420.05n

.meas tran vdout0_10ck410 FIND v(dout0_10) AT=420.05n

.meas tran vdout0_11ck410 FIND v(dout0_11) AT=420.05n

.meas tran vdout0_12ck410 FIND v(dout0_12) AT=420.05n

.meas tran vdout0_13ck410 FIND v(dout0_13) AT=420.05n

.meas tran vdout0_14ck410 FIND v(dout0_14) AT=420.05n

.meas tran vdout0_15ck410 FIND v(dout0_15) AT=420.05n

.meas tran vdout0_0ck440 FIND v(dout0_0) AT=450.05n

.meas tran vdout0_1ck440 FIND v(dout0_1) AT=450.05n

.meas tran vdout0_2ck440 FIND v(dout0_2) AT=450.05n

.meas tran vdout0_3ck440 FIND v(dout0_3) AT=450.05n

.meas tran vdout0_4ck440 FIND v(dout0_4) AT=450.05n

.meas tran vdout0_5ck440 FIND v(dout0_5) AT=450.05n

.meas tran vdout0_6ck440 FIND v(dout0_6) AT=450.05n

.meas tran vdout0_7ck440 FIND v(dout0_7) AT=450.05n

.meas tran vdout0_8ck440 FIND v(dout0_8) AT=450.05n

.meas tran vdout0_9ck440 FIND v(dout0_9) AT=450.05n

.meas tran vdout0_10ck440 FIND v(dout0_10) AT=450.05n

.meas tran vdout0_11ck440 FIND v(dout0_11) AT=450.05n

.meas tran vdout0_12ck440 FIND v(dout0_12) AT=450.05n

.meas tran vdout0_13ck440 FIND v(dout0_13) AT=450.05n

.meas tran vdout0_14ck440 FIND v(dout0_14) AT=450.05n

.meas tran vdout0_15ck440 FIND v(dout0_15) AT=450.05n

.meas tran vdout0_0ck460 FIND v(dout0_0) AT=470.05n

.meas tran vdout0_1ck460 FIND v(dout0_1) AT=470.05n

.meas tran vdout0_2ck460 FIND v(dout0_2) AT=470.05n

.meas tran vdout0_3ck460 FIND v(dout0_3) AT=470.05n

.meas tran vdout0_4ck460 FIND v(dout0_4) AT=470.05n

.meas tran vdout0_5ck460 FIND v(dout0_5) AT=470.05n

.meas tran vdout0_6ck460 FIND v(dout0_6) AT=470.05n

.meas tran vdout0_7ck460 FIND v(dout0_7) AT=470.05n

.meas tran vdout0_8ck460 FIND v(dout0_8) AT=470.05n

.meas tran vdout0_9ck460 FIND v(dout0_9) AT=470.05n

.meas tran vdout0_10ck460 FIND v(dout0_10) AT=470.05n

.meas tran vdout0_11ck460 FIND v(dout0_11) AT=470.05n

.meas tran vdout0_12ck460 FIND v(dout0_12) AT=470.05n

.meas tran vdout0_13ck460 FIND v(dout0_13) AT=470.05n

.meas tran vdout0_14ck460 FIND v(dout0_14) AT=470.05n

.meas tran vdout0_15ck460 FIND v(dout0_15) AT=470.05n

.meas tran vdout0_0ck470 FIND v(dout0_0) AT=480.05n

.meas tran vdout0_1ck470 FIND v(dout0_1) AT=480.05n

.meas tran vdout0_2ck470 FIND v(dout0_2) AT=480.05n

.meas tran vdout0_3ck470 FIND v(dout0_3) AT=480.05n

.meas tran vdout0_4ck470 FIND v(dout0_4) AT=480.05n

.meas tran vdout0_5ck470 FIND v(dout0_5) AT=480.05n

.meas tran vdout0_6ck470 FIND v(dout0_6) AT=480.05n

.meas tran vdout0_7ck470 FIND v(dout0_7) AT=480.05n

.meas tran vdout0_8ck470 FIND v(dout0_8) AT=480.05n

.meas tran vdout0_9ck470 FIND v(dout0_9) AT=480.05n

.meas tran vdout0_10ck470 FIND v(dout0_10) AT=480.05n

.meas tran vdout0_11ck470 FIND v(dout0_11) AT=480.05n

.meas tran vdout0_12ck470 FIND v(dout0_12) AT=480.05n

.meas tran vdout0_13ck470 FIND v(dout0_13) AT=480.05n

.meas tran vdout0_14ck470 FIND v(dout0_14) AT=480.05n

.meas tran vdout0_15ck470 FIND v(dout0_15) AT=480.05n

.meas tran vdout0_0ck480 FIND v(dout0_0) AT=490.05n

.meas tran vdout0_1ck480 FIND v(dout0_1) AT=490.05n

.meas tran vdout0_2ck480 FIND v(dout0_2) AT=490.05n

.meas tran vdout0_3ck480 FIND v(dout0_3) AT=490.05n

.meas tran vdout0_4ck480 FIND v(dout0_4) AT=490.05n

.meas tran vdout0_5ck480 FIND v(dout0_5) AT=490.05n

.meas tran vdout0_6ck480 FIND v(dout0_6) AT=490.05n

.meas tran vdout0_7ck480 FIND v(dout0_7) AT=490.05n

.meas tran vdout0_8ck480 FIND v(dout0_8) AT=490.05n

.meas tran vdout0_9ck480 FIND v(dout0_9) AT=490.05n

.meas tran vdout0_10ck480 FIND v(dout0_10) AT=490.05n

.meas tran vdout0_11ck480 FIND v(dout0_11) AT=490.05n

.meas tran vdout0_12ck480 FIND v(dout0_12) AT=490.05n

.meas tran vdout0_13ck480 FIND v(dout0_13) AT=490.05n

.meas tran vdout0_14ck480 FIND v(dout0_14) AT=490.05n

.meas tran vdout0_15ck480 FIND v(dout0_15) AT=490.05n

.meas tran vdout0_0ck510 FIND v(dout0_0) AT=520.05n

.meas tran vdout0_1ck510 FIND v(dout0_1) AT=520.05n

.meas tran vdout0_2ck510 FIND v(dout0_2) AT=520.05n

.meas tran vdout0_3ck510 FIND v(dout0_3) AT=520.05n

.meas tran vdout0_4ck510 FIND v(dout0_4) AT=520.05n

.meas tran vdout0_5ck510 FIND v(dout0_5) AT=520.05n

.meas tran vdout0_6ck510 FIND v(dout0_6) AT=520.05n

.meas tran vdout0_7ck510 FIND v(dout0_7) AT=520.05n

.meas tran vdout0_8ck510 FIND v(dout0_8) AT=520.05n

.meas tran vdout0_9ck510 FIND v(dout0_9) AT=520.05n

.meas tran vdout0_10ck510 FIND v(dout0_10) AT=520.05n

.meas tran vdout0_11ck510 FIND v(dout0_11) AT=520.05n

.meas tran vdout0_12ck510 FIND v(dout0_12) AT=520.05n

.meas tran vdout0_13ck510 FIND v(dout0_13) AT=520.05n

.meas tran vdout0_14ck510 FIND v(dout0_14) AT=520.05n

.meas tran vdout0_15ck510 FIND v(dout0_15) AT=520.05n

.meas tran vdout0_0ck530 FIND v(dout0_0) AT=540.05n

.meas tran vdout0_1ck530 FIND v(dout0_1) AT=540.05n

.meas tran vdout0_2ck530 FIND v(dout0_2) AT=540.05n

.meas tran vdout0_3ck530 FIND v(dout0_3) AT=540.05n

.meas tran vdout0_4ck530 FIND v(dout0_4) AT=540.05n

.meas tran vdout0_5ck530 FIND v(dout0_5) AT=540.05n

.meas tran vdout0_6ck530 FIND v(dout0_6) AT=540.05n

.meas tran vdout0_7ck530 FIND v(dout0_7) AT=540.05n

.meas tran vdout0_8ck530 FIND v(dout0_8) AT=540.05n

.meas tran vdout0_9ck530 FIND v(dout0_9) AT=540.05n

.meas tran vdout0_10ck530 FIND v(dout0_10) AT=540.05n

.meas tran vdout0_11ck530 FIND v(dout0_11) AT=540.05n

.meas tran vdout0_12ck530 FIND v(dout0_12) AT=540.05n

.meas tran vdout0_13ck530 FIND v(dout0_13) AT=540.05n

.meas tran vdout0_14ck530 FIND v(dout0_14) AT=540.05n

.meas tran vdout0_15ck530 FIND v(dout0_15) AT=540.05n

.meas tran vdout0_0ck540 FIND v(dout0_0) AT=550.05n

.meas tran vdout0_1ck540 FIND v(dout0_1) AT=550.05n

.meas tran vdout0_2ck540 FIND v(dout0_2) AT=550.05n

.meas tran vdout0_3ck540 FIND v(dout0_3) AT=550.05n

.meas tran vdout0_4ck540 FIND v(dout0_4) AT=550.05n

.meas tran vdout0_5ck540 FIND v(dout0_5) AT=550.05n

.meas tran vdout0_6ck540 FIND v(dout0_6) AT=550.05n

.meas tran vdout0_7ck540 FIND v(dout0_7) AT=550.05n

.meas tran vdout0_8ck540 FIND v(dout0_8) AT=550.05n

.meas tran vdout0_9ck540 FIND v(dout0_9) AT=550.05n

.meas tran vdout0_10ck540 FIND v(dout0_10) AT=550.05n

.meas tran vdout0_11ck540 FIND v(dout0_11) AT=550.05n

.meas tran vdout0_12ck540 FIND v(dout0_12) AT=550.05n

.meas tran vdout0_13ck540 FIND v(dout0_13) AT=550.05n

.meas tran vdout0_14ck540 FIND v(dout0_14) AT=550.05n

.meas tran vdout0_15ck540 FIND v(dout0_15) AT=550.05n

.meas tran vdout0_0ck550 FIND v(dout0_0) AT=560.05n

.meas tran vdout0_1ck550 FIND v(dout0_1) AT=560.05n

.meas tran vdout0_2ck550 FIND v(dout0_2) AT=560.05n

.meas tran vdout0_3ck550 FIND v(dout0_3) AT=560.05n

.meas tran vdout0_4ck550 FIND v(dout0_4) AT=560.05n

.meas tran vdout0_5ck550 FIND v(dout0_5) AT=560.05n

.meas tran vdout0_6ck550 FIND v(dout0_6) AT=560.05n

.meas tran vdout0_7ck550 FIND v(dout0_7) AT=560.05n

.meas tran vdout0_8ck550 FIND v(dout0_8) AT=560.05n

.meas tran vdout0_9ck550 FIND v(dout0_9) AT=560.05n

.meas tran vdout0_10ck550 FIND v(dout0_10) AT=560.05n

.meas tran vdout0_11ck550 FIND v(dout0_11) AT=560.05n

.meas tran vdout0_12ck550 FIND v(dout0_12) AT=560.05n

.meas tran vdout0_13ck550 FIND v(dout0_13) AT=560.05n

.meas tran vdout0_14ck550 FIND v(dout0_14) AT=560.05n

.meas tran vdout0_15ck550 FIND v(dout0_15) AT=560.05n

.meas tran vdout0_0ck570 FIND v(dout0_0) AT=580.05n

.meas tran vdout0_1ck570 FIND v(dout0_1) AT=580.05n

.meas tran vdout0_2ck570 FIND v(dout0_2) AT=580.05n

.meas tran vdout0_3ck570 FIND v(dout0_3) AT=580.05n

.meas tran vdout0_4ck570 FIND v(dout0_4) AT=580.05n

.meas tran vdout0_5ck570 FIND v(dout0_5) AT=580.05n

.meas tran vdout0_6ck570 FIND v(dout0_6) AT=580.05n

.meas tran vdout0_7ck570 FIND v(dout0_7) AT=580.05n

.meas tran vdout0_8ck570 FIND v(dout0_8) AT=580.05n

.meas tran vdout0_9ck570 FIND v(dout0_9) AT=580.05n

.meas tran vdout0_10ck570 FIND v(dout0_10) AT=580.05n

.meas tran vdout0_11ck570 FIND v(dout0_11) AT=580.05n

.meas tran vdout0_12ck570 FIND v(dout0_12) AT=580.05n

.meas tran vdout0_13ck570 FIND v(dout0_13) AT=580.05n

.meas tran vdout0_14ck570 FIND v(dout0_14) AT=580.05n

.meas tran vdout0_15ck570 FIND v(dout0_15) AT=580.05n

.meas tran vdout0_0ck580 FIND v(dout0_0) AT=590.05n

.meas tran vdout0_1ck580 FIND v(dout0_1) AT=590.05n

.meas tran vdout0_2ck580 FIND v(dout0_2) AT=590.05n

.meas tran vdout0_3ck580 FIND v(dout0_3) AT=590.05n

.meas tran vdout0_4ck580 FIND v(dout0_4) AT=590.05n

.meas tran vdout0_5ck580 FIND v(dout0_5) AT=590.05n

.meas tran vdout0_6ck580 FIND v(dout0_6) AT=590.05n

.meas tran vdout0_7ck580 FIND v(dout0_7) AT=590.05n

.meas tran vdout0_8ck580 FIND v(dout0_8) AT=590.05n

.meas tran vdout0_9ck580 FIND v(dout0_9) AT=590.05n

.meas tran vdout0_10ck580 FIND v(dout0_10) AT=590.05n

.meas tran vdout0_11ck580 FIND v(dout0_11) AT=590.05n

.meas tran vdout0_12ck580 FIND v(dout0_12) AT=590.05n

.meas tran vdout0_13ck580 FIND v(dout0_13) AT=590.05n

.meas tran vdout0_14ck580 FIND v(dout0_14) AT=590.05n

.meas tran vdout0_15ck580 FIND v(dout0_15) AT=590.05n

.meas tran vdout0_0ck590 FIND v(dout0_0) AT=600.05n

.meas tran vdout0_1ck590 FIND v(dout0_1) AT=600.05n

.meas tran vdout0_2ck590 FIND v(dout0_2) AT=600.05n

.meas tran vdout0_3ck590 FIND v(dout0_3) AT=600.05n

.meas tran vdout0_4ck590 FIND v(dout0_4) AT=600.05n

.meas tran vdout0_5ck590 FIND v(dout0_5) AT=600.05n

.meas tran vdout0_6ck590 FIND v(dout0_6) AT=600.05n

.meas tran vdout0_7ck590 FIND v(dout0_7) AT=600.05n

.meas tran vdout0_8ck590 FIND v(dout0_8) AT=600.05n

.meas tran vdout0_9ck590 FIND v(dout0_9) AT=600.05n

.meas tran vdout0_10ck590 FIND v(dout0_10) AT=600.05n

.meas tran vdout0_11ck590 FIND v(dout0_11) AT=600.05n

.meas tran vdout0_12ck590 FIND v(dout0_12) AT=600.05n

.meas tran vdout0_13ck590 FIND v(dout0_13) AT=600.05n

.meas tran vdout0_14ck590 FIND v(dout0_14) AT=600.05n

.meas tran vdout0_15ck590 FIND v(dout0_15) AT=600.05n

.meas tran vdout0_0ck600 FIND v(dout0_0) AT=610.05n

.meas tran vdout0_1ck600 FIND v(dout0_1) AT=610.05n

.meas tran vdout0_2ck600 FIND v(dout0_2) AT=610.05n

.meas tran vdout0_3ck600 FIND v(dout0_3) AT=610.05n

.meas tran vdout0_4ck600 FIND v(dout0_4) AT=610.05n

.meas tran vdout0_5ck600 FIND v(dout0_5) AT=610.05n

.meas tran vdout0_6ck600 FIND v(dout0_6) AT=610.05n

.meas tran vdout0_7ck600 FIND v(dout0_7) AT=610.05n

.meas tran vdout0_8ck600 FIND v(dout0_8) AT=610.05n

.meas tran vdout0_9ck600 FIND v(dout0_9) AT=610.05n

.meas tran vdout0_10ck600 FIND v(dout0_10) AT=610.05n

.meas tran vdout0_11ck600 FIND v(dout0_11) AT=610.05n

.meas tran vdout0_12ck600 FIND v(dout0_12) AT=610.05n

.meas tran vdout0_13ck600 FIND v(dout0_13) AT=610.05n

.meas tran vdout0_14ck600 FIND v(dout0_14) AT=610.05n

.meas tran vdout0_15ck600 FIND v(dout0_15) AT=610.05n

.meas tran vdout0_0ck610 FIND v(dout0_0) AT=620.05n

.meas tran vdout0_1ck610 FIND v(dout0_1) AT=620.05n

.meas tran vdout0_2ck610 FIND v(dout0_2) AT=620.05n

.meas tran vdout0_3ck610 FIND v(dout0_3) AT=620.05n

.meas tran vdout0_4ck610 FIND v(dout0_4) AT=620.05n

.meas tran vdout0_5ck610 FIND v(dout0_5) AT=620.05n

.meas tran vdout0_6ck610 FIND v(dout0_6) AT=620.05n

.meas tran vdout0_7ck610 FIND v(dout0_7) AT=620.05n

.meas tran vdout0_8ck610 FIND v(dout0_8) AT=620.05n

.meas tran vdout0_9ck610 FIND v(dout0_9) AT=620.05n

.meas tran vdout0_10ck610 FIND v(dout0_10) AT=620.05n

.meas tran vdout0_11ck610 FIND v(dout0_11) AT=620.05n

.meas tran vdout0_12ck610 FIND v(dout0_12) AT=620.05n

.meas tran vdout0_13ck610 FIND v(dout0_13) AT=620.05n

.meas tran vdout0_14ck610 FIND v(dout0_14) AT=620.05n

.meas tran vdout0_15ck610 FIND v(dout0_15) AT=620.05n

.meas tran vdout0_0ck660 FIND v(dout0_0) AT=670.05n

.meas tran vdout0_1ck660 FIND v(dout0_1) AT=670.05n

.meas tran vdout0_2ck660 FIND v(dout0_2) AT=670.05n

.meas tran vdout0_3ck660 FIND v(dout0_3) AT=670.05n

.meas tran vdout0_4ck660 FIND v(dout0_4) AT=670.05n

.meas tran vdout0_5ck660 FIND v(dout0_5) AT=670.05n

.meas tran vdout0_6ck660 FIND v(dout0_6) AT=670.05n

.meas tran vdout0_7ck660 FIND v(dout0_7) AT=670.05n

.meas tran vdout0_8ck660 FIND v(dout0_8) AT=670.05n

.meas tran vdout0_9ck660 FIND v(dout0_9) AT=670.05n

.meas tran vdout0_10ck660 FIND v(dout0_10) AT=670.05n

.meas tran vdout0_11ck660 FIND v(dout0_11) AT=670.05n

.meas tran vdout0_12ck660 FIND v(dout0_12) AT=670.05n

.meas tran vdout0_13ck660 FIND v(dout0_13) AT=670.05n

.meas tran vdout0_14ck660 FIND v(dout0_14) AT=670.05n

.meas tran vdout0_15ck660 FIND v(dout0_15) AT=670.05n

.meas tran vdout0_0ck670 FIND v(dout0_0) AT=680.05n

.meas tran vdout0_1ck670 FIND v(dout0_1) AT=680.05n

.meas tran vdout0_2ck670 FIND v(dout0_2) AT=680.05n

.meas tran vdout0_3ck670 FIND v(dout0_3) AT=680.05n

.meas tran vdout0_4ck670 FIND v(dout0_4) AT=680.05n

.meas tran vdout0_5ck670 FIND v(dout0_5) AT=680.05n

.meas tran vdout0_6ck670 FIND v(dout0_6) AT=680.05n

.meas tran vdout0_7ck670 FIND v(dout0_7) AT=680.05n

.meas tran vdout0_8ck670 FIND v(dout0_8) AT=680.05n

.meas tran vdout0_9ck670 FIND v(dout0_9) AT=680.05n

.meas tran vdout0_10ck670 FIND v(dout0_10) AT=680.05n

.meas tran vdout0_11ck670 FIND v(dout0_11) AT=680.05n

.meas tran vdout0_12ck670 FIND v(dout0_12) AT=680.05n

.meas tran vdout0_13ck670 FIND v(dout0_13) AT=680.05n

.meas tran vdout0_14ck670 FIND v(dout0_14) AT=680.05n

.meas tran vdout0_15ck670 FIND v(dout0_15) AT=680.05n

.meas tran vdout0_0ck690 FIND v(dout0_0) AT=700.05n

.meas tran vdout0_1ck690 FIND v(dout0_1) AT=700.05n

.meas tran vdout0_2ck690 FIND v(dout0_2) AT=700.05n

.meas tran vdout0_3ck690 FIND v(dout0_3) AT=700.05n

.meas tran vdout0_4ck690 FIND v(dout0_4) AT=700.05n

.meas tran vdout0_5ck690 FIND v(dout0_5) AT=700.05n

.meas tran vdout0_6ck690 FIND v(dout0_6) AT=700.05n

.meas tran vdout0_7ck690 FIND v(dout0_7) AT=700.05n

.meas tran vdout0_8ck690 FIND v(dout0_8) AT=700.05n

.meas tran vdout0_9ck690 FIND v(dout0_9) AT=700.05n

.meas tran vdout0_10ck690 FIND v(dout0_10) AT=700.05n

.meas tran vdout0_11ck690 FIND v(dout0_11) AT=700.05n

.meas tran vdout0_12ck690 FIND v(dout0_12) AT=700.05n

.meas tran vdout0_13ck690 FIND v(dout0_13) AT=700.05n

.meas tran vdout0_14ck690 FIND v(dout0_14) AT=700.05n

.meas tran vdout0_15ck690 FIND v(dout0_15) AT=700.05n

.meas tran vdout0_0ck710 FIND v(dout0_0) AT=720.05n

.meas tran vdout0_1ck710 FIND v(dout0_1) AT=720.05n

.meas tran vdout0_2ck710 FIND v(dout0_2) AT=720.05n

.meas tran vdout0_3ck710 FIND v(dout0_3) AT=720.05n

.meas tran vdout0_4ck710 FIND v(dout0_4) AT=720.05n

.meas tran vdout0_5ck710 FIND v(dout0_5) AT=720.05n

.meas tran vdout0_6ck710 FIND v(dout0_6) AT=720.05n

.meas tran vdout0_7ck710 FIND v(dout0_7) AT=720.05n

.meas tran vdout0_8ck710 FIND v(dout0_8) AT=720.05n

.meas tran vdout0_9ck710 FIND v(dout0_9) AT=720.05n

.meas tran vdout0_10ck710 FIND v(dout0_10) AT=720.05n

.meas tran vdout0_11ck710 FIND v(dout0_11) AT=720.05n

.meas tran vdout0_12ck710 FIND v(dout0_12) AT=720.05n

.meas tran vdout0_13ck710 FIND v(dout0_13) AT=720.05n

.meas tran vdout0_14ck710 FIND v(dout0_14) AT=720.05n

.meas tran vdout0_15ck710 FIND v(dout0_15) AT=720.05n

.meas tran vdout0_0ck720 FIND v(dout0_0) AT=730.05n

.meas tran vdout0_1ck720 FIND v(dout0_1) AT=730.05n

.meas tran vdout0_2ck720 FIND v(dout0_2) AT=730.05n

.meas tran vdout0_3ck720 FIND v(dout0_3) AT=730.05n

.meas tran vdout0_4ck720 FIND v(dout0_4) AT=730.05n

.meas tran vdout0_5ck720 FIND v(dout0_5) AT=730.05n

.meas tran vdout0_6ck720 FIND v(dout0_6) AT=730.05n

.meas tran vdout0_7ck720 FIND v(dout0_7) AT=730.05n

.meas tran vdout0_8ck720 FIND v(dout0_8) AT=730.05n

.meas tran vdout0_9ck720 FIND v(dout0_9) AT=730.05n

.meas tran vdout0_10ck720 FIND v(dout0_10) AT=730.05n

.meas tran vdout0_11ck720 FIND v(dout0_11) AT=730.05n

.meas tran vdout0_12ck720 FIND v(dout0_12) AT=730.05n

.meas tran vdout0_13ck720 FIND v(dout0_13) AT=730.05n

.meas tran vdout0_14ck720 FIND v(dout0_14) AT=730.05n

.meas tran vdout0_15ck720 FIND v(dout0_15) AT=730.05n

.meas tran vdout0_0ck730 FIND v(dout0_0) AT=740.05n

.meas tran vdout0_1ck730 FIND v(dout0_1) AT=740.05n

.meas tran vdout0_2ck730 FIND v(dout0_2) AT=740.05n

.meas tran vdout0_3ck730 FIND v(dout0_3) AT=740.05n

.meas tran vdout0_4ck730 FIND v(dout0_4) AT=740.05n

.meas tran vdout0_5ck730 FIND v(dout0_5) AT=740.05n

.meas tran vdout0_6ck730 FIND v(dout0_6) AT=740.05n

.meas tran vdout0_7ck730 FIND v(dout0_7) AT=740.05n

.meas tran vdout0_8ck730 FIND v(dout0_8) AT=740.05n

.meas tran vdout0_9ck730 FIND v(dout0_9) AT=740.05n

.meas tran vdout0_10ck730 FIND v(dout0_10) AT=740.05n

.meas tran vdout0_11ck730 FIND v(dout0_11) AT=740.05n

.meas tran vdout0_12ck730 FIND v(dout0_12) AT=740.05n

.meas tran vdout0_13ck730 FIND v(dout0_13) AT=740.05n

.meas tran vdout0_14ck730 FIND v(dout0_14) AT=740.05n

.meas tran vdout0_15ck730 FIND v(dout0_15) AT=740.05n

.meas tran vdout0_0ck740 FIND v(dout0_0) AT=750.05n

.meas tran vdout0_1ck740 FIND v(dout0_1) AT=750.05n

.meas tran vdout0_2ck740 FIND v(dout0_2) AT=750.05n

.meas tran vdout0_3ck740 FIND v(dout0_3) AT=750.05n

.meas tran vdout0_4ck740 FIND v(dout0_4) AT=750.05n

.meas tran vdout0_5ck740 FIND v(dout0_5) AT=750.05n

.meas tran vdout0_6ck740 FIND v(dout0_6) AT=750.05n

.meas tran vdout0_7ck740 FIND v(dout0_7) AT=750.05n

.meas tran vdout0_8ck740 FIND v(dout0_8) AT=750.05n

.meas tran vdout0_9ck740 FIND v(dout0_9) AT=750.05n

.meas tran vdout0_10ck740 FIND v(dout0_10) AT=750.05n

.meas tran vdout0_11ck740 FIND v(dout0_11) AT=750.05n

.meas tran vdout0_12ck740 FIND v(dout0_12) AT=750.05n

.meas tran vdout0_13ck740 FIND v(dout0_13) AT=750.05n

.meas tran vdout0_14ck740 FIND v(dout0_14) AT=750.05n

.meas tran vdout0_15ck740 FIND v(dout0_15) AT=750.05n

.meas tran vdout0_0ck770 FIND v(dout0_0) AT=780.05n

.meas tran vdout0_1ck770 FIND v(dout0_1) AT=780.05n

.meas tran vdout0_2ck770 FIND v(dout0_2) AT=780.05n

.meas tran vdout0_3ck770 FIND v(dout0_3) AT=780.05n

.meas tran vdout0_4ck770 FIND v(dout0_4) AT=780.05n

.meas tran vdout0_5ck770 FIND v(dout0_5) AT=780.05n

.meas tran vdout0_6ck770 FIND v(dout0_6) AT=780.05n

.meas tran vdout0_7ck770 FIND v(dout0_7) AT=780.05n

.meas tran vdout0_8ck770 FIND v(dout0_8) AT=780.05n

.meas tran vdout0_9ck770 FIND v(dout0_9) AT=780.05n

.meas tran vdout0_10ck770 FIND v(dout0_10) AT=780.05n

.meas tran vdout0_11ck770 FIND v(dout0_11) AT=780.05n

.meas tran vdout0_12ck770 FIND v(dout0_12) AT=780.05n

.meas tran vdout0_13ck770 FIND v(dout0_13) AT=780.05n

.meas tran vdout0_14ck770 FIND v(dout0_14) AT=780.05n

.meas tran vdout0_15ck770 FIND v(dout0_15) AT=780.05n

.meas tran vdout0_0ck800 FIND v(dout0_0) AT=810.05n

.meas tran vdout0_1ck800 FIND v(dout0_1) AT=810.05n

.meas tran vdout0_2ck800 FIND v(dout0_2) AT=810.05n

.meas tran vdout0_3ck800 FIND v(dout0_3) AT=810.05n

.meas tran vdout0_4ck800 FIND v(dout0_4) AT=810.05n

.meas tran vdout0_5ck800 FIND v(dout0_5) AT=810.05n

.meas tran vdout0_6ck800 FIND v(dout0_6) AT=810.05n

.meas tran vdout0_7ck800 FIND v(dout0_7) AT=810.05n

.meas tran vdout0_8ck800 FIND v(dout0_8) AT=810.05n

.meas tran vdout0_9ck800 FIND v(dout0_9) AT=810.05n

.meas tran vdout0_10ck800 FIND v(dout0_10) AT=810.05n

.meas tran vdout0_11ck800 FIND v(dout0_11) AT=810.05n

.meas tran vdout0_12ck800 FIND v(dout0_12) AT=810.05n

.meas tran vdout0_13ck800 FIND v(dout0_13) AT=810.05n

.meas tran vdout0_14ck800 FIND v(dout0_14) AT=810.05n

.meas tran vdout0_15ck800 FIND v(dout0_15) AT=810.05n

.meas tran vdout0_0ck810 FIND v(dout0_0) AT=820.05n

.meas tran vdout0_1ck810 FIND v(dout0_1) AT=820.05n

.meas tran vdout0_2ck810 FIND v(dout0_2) AT=820.05n

.meas tran vdout0_3ck810 FIND v(dout0_3) AT=820.05n

.meas tran vdout0_4ck810 FIND v(dout0_4) AT=820.05n

.meas tran vdout0_5ck810 FIND v(dout0_5) AT=820.05n

.meas tran vdout0_6ck810 FIND v(dout0_6) AT=820.05n

.meas tran vdout0_7ck810 FIND v(dout0_7) AT=820.05n

.meas tran vdout0_8ck810 FIND v(dout0_8) AT=820.05n

.meas tran vdout0_9ck810 FIND v(dout0_9) AT=820.05n

.meas tran vdout0_10ck810 FIND v(dout0_10) AT=820.05n

.meas tran vdout0_11ck810 FIND v(dout0_11) AT=820.05n

.meas tran vdout0_12ck810 FIND v(dout0_12) AT=820.05n

.meas tran vdout0_13ck810 FIND v(dout0_13) AT=820.05n

.meas tran vdout0_14ck810 FIND v(dout0_14) AT=820.05n

.meas tran vdout0_15ck810 FIND v(dout0_15) AT=820.05n

.meas tran vdout0_0ck820 FIND v(dout0_0) AT=830.05n

.meas tran vdout0_1ck820 FIND v(dout0_1) AT=830.05n

.meas tran vdout0_2ck820 FIND v(dout0_2) AT=830.05n

.meas tran vdout0_3ck820 FIND v(dout0_3) AT=830.05n

.meas tran vdout0_4ck820 FIND v(dout0_4) AT=830.05n

.meas tran vdout0_5ck820 FIND v(dout0_5) AT=830.05n

.meas tran vdout0_6ck820 FIND v(dout0_6) AT=830.05n

.meas tran vdout0_7ck820 FIND v(dout0_7) AT=830.05n

.meas tran vdout0_8ck820 FIND v(dout0_8) AT=830.05n

.meas tran vdout0_9ck820 FIND v(dout0_9) AT=830.05n

.meas tran vdout0_10ck820 FIND v(dout0_10) AT=830.05n

.meas tran vdout0_11ck820 FIND v(dout0_11) AT=830.05n

.meas tran vdout0_12ck820 FIND v(dout0_12) AT=830.05n

.meas tran vdout0_13ck820 FIND v(dout0_13) AT=830.05n

.meas tran vdout0_14ck820 FIND v(dout0_14) AT=830.05n

.meas tran vdout0_15ck820 FIND v(dout0_15) AT=830.05n

.meas tran vdout0_0ck830 FIND v(dout0_0) AT=840.05n

.meas tran vdout0_1ck830 FIND v(dout0_1) AT=840.05n

.meas tran vdout0_2ck830 FIND v(dout0_2) AT=840.05n

.meas tran vdout0_3ck830 FIND v(dout0_3) AT=840.05n

.meas tran vdout0_4ck830 FIND v(dout0_4) AT=840.05n

.meas tran vdout0_5ck830 FIND v(dout0_5) AT=840.05n

.meas tran vdout0_6ck830 FIND v(dout0_6) AT=840.05n

.meas tran vdout0_7ck830 FIND v(dout0_7) AT=840.05n

.meas tran vdout0_8ck830 FIND v(dout0_8) AT=840.05n

.meas tran vdout0_9ck830 FIND v(dout0_9) AT=840.05n

.meas tran vdout0_10ck830 FIND v(dout0_10) AT=840.05n

.meas tran vdout0_11ck830 FIND v(dout0_11) AT=840.05n

.meas tran vdout0_12ck830 FIND v(dout0_12) AT=840.05n

.meas tran vdout0_13ck830 FIND v(dout0_13) AT=840.05n

.meas tran vdout0_14ck830 FIND v(dout0_14) AT=840.05n

.meas tran vdout0_15ck830 FIND v(dout0_15) AT=840.05n

.meas tran vdout0_0ck850 FIND v(dout0_0) AT=860.05n

.meas tran vdout0_1ck850 FIND v(dout0_1) AT=860.05n

.meas tran vdout0_2ck850 FIND v(dout0_2) AT=860.05n

.meas tran vdout0_3ck850 FIND v(dout0_3) AT=860.05n

.meas tran vdout0_4ck850 FIND v(dout0_4) AT=860.05n

.meas tran vdout0_5ck850 FIND v(dout0_5) AT=860.05n

.meas tran vdout0_6ck850 FIND v(dout0_6) AT=860.05n

.meas tran vdout0_7ck850 FIND v(dout0_7) AT=860.05n

.meas tran vdout0_8ck850 FIND v(dout0_8) AT=860.05n

.meas tran vdout0_9ck850 FIND v(dout0_9) AT=860.05n

.meas tran vdout0_10ck850 FIND v(dout0_10) AT=860.05n

.meas tran vdout0_11ck850 FIND v(dout0_11) AT=860.05n

.meas tran vdout0_12ck850 FIND v(dout0_12) AT=860.05n

.meas tran vdout0_13ck850 FIND v(dout0_13) AT=860.05n

.meas tran vdout0_14ck850 FIND v(dout0_14) AT=860.05n

.meas tran vdout0_15ck850 FIND v(dout0_15) AT=860.05n

.meas tran vdout0_0ck860 FIND v(dout0_0) AT=870.05n

.meas tran vdout0_1ck860 FIND v(dout0_1) AT=870.05n

.meas tran vdout0_2ck860 FIND v(dout0_2) AT=870.05n

.meas tran vdout0_3ck860 FIND v(dout0_3) AT=870.05n

.meas tran vdout0_4ck860 FIND v(dout0_4) AT=870.05n

.meas tran vdout0_5ck860 FIND v(dout0_5) AT=870.05n

.meas tran vdout0_6ck860 FIND v(dout0_6) AT=870.05n

.meas tran vdout0_7ck860 FIND v(dout0_7) AT=870.05n

.meas tran vdout0_8ck860 FIND v(dout0_8) AT=870.05n

.meas tran vdout0_9ck860 FIND v(dout0_9) AT=870.05n

.meas tran vdout0_10ck860 FIND v(dout0_10) AT=870.05n

.meas tran vdout0_11ck860 FIND v(dout0_11) AT=870.05n

.meas tran vdout0_12ck860 FIND v(dout0_12) AT=870.05n

.meas tran vdout0_13ck860 FIND v(dout0_13) AT=870.05n

.meas tran vdout0_14ck860 FIND v(dout0_14) AT=870.05n

.meas tran vdout0_15ck860 FIND v(dout0_15) AT=870.05n

.meas tran vdout0_0ck870 FIND v(dout0_0) AT=880.05n

.meas tran vdout0_1ck870 FIND v(dout0_1) AT=880.05n

.meas tran vdout0_2ck870 FIND v(dout0_2) AT=880.05n

.meas tran vdout0_3ck870 FIND v(dout0_3) AT=880.05n

.meas tran vdout0_4ck870 FIND v(dout0_4) AT=880.05n

.meas tran vdout0_5ck870 FIND v(dout0_5) AT=880.05n

.meas tran vdout0_6ck870 FIND v(dout0_6) AT=880.05n

.meas tran vdout0_7ck870 FIND v(dout0_7) AT=880.05n

.meas tran vdout0_8ck870 FIND v(dout0_8) AT=880.05n

.meas tran vdout0_9ck870 FIND v(dout0_9) AT=880.05n

.meas tran vdout0_10ck870 FIND v(dout0_10) AT=880.05n

.meas tran vdout0_11ck870 FIND v(dout0_11) AT=880.05n

.meas tran vdout0_12ck870 FIND v(dout0_12) AT=880.05n

.meas tran vdout0_13ck870 FIND v(dout0_13) AT=880.05n

.meas tran vdout0_14ck870 FIND v(dout0_14) AT=880.05n

.meas tran vdout0_15ck870 FIND v(dout0_15) AT=880.05n

.meas tran vdout0_0ck890 FIND v(dout0_0) AT=900.05n

.meas tran vdout0_1ck890 FIND v(dout0_1) AT=900.05n

.meas tran vdout0_2ck890 FIND v(dout0_2) AT=900.05n

.meas tran vdout0_3ck890 FIND v(dout0_3) AT=900.05n

.meas tran vdout0_4ck890 FIND v(dout0_4) AT=900.05n

.meas tran vdout0_5ck890 FIND v(dout0_5) AT=900.05n

.meas tran vdout0_6ck890 FIND v(dout0_6) AT=900.05n

.meas tran vdout0_7ck890 FIND v(dout0_7) AT=900.05n

.meas tran vdout0_8ck890 FIND v(dout0_8) AT=900.05n

.meas tran vdout0_9ck890 FIND v(dout0_9) AT=900.05n

.meas tran vdout0_10ck890 FIND v(dout0_10) AT=900.05n

.meas tran vdout0_11ck890 FIND v(dout0_11) AT=900.05n

.meas tran vdout0_12ck890 FIND v(dout0_12) AT=900.05n

.meas tran vdout0_13ck890 FIND v(dout0_13) AT=900.05n

.meas tran vdout0_14ck890 FIND v(dout0_14) AT=900.05n

.meas tran vdout0_15ck890 FIND v(dout0_15) AT=900.05n

.meas tran vdout0_0ck910 FIND v(dout0_0) AT=920.05n

.meas tran vdout0_1ck910 FIND v(dout0_1) AT=920.05n

.meas tran vdout0_2ck910 FIND v(dout0_2) AT=920.05n

.meas tran vdout0_3ck910 FIND v(dout0_3) AT=920.05n

.meas tran vdout0_4ck910 FIND v(dout0_4) AT=920.05n

.meas tran vdout0_5ck910 FIND v(dout0_5) AT=920.05n

.meas tran vdout0_6ck910 FIND v(dout0_6) AT=920.05n

.meas tran vdout0_7ck910 FIND v(dout0_7) AT=920.05n

.meas tran vdout0_8ck910 FIND v(dout0_8) AT=920.05n

.meas tran vdout0_9ck910 FIND v(dout0_9) AT=920.05n

.meas tran vdout0_10ck910 FIND v(dout0_10) AT=920.05n

.meas tran vdout0_11ck910 FIND v(dout0_11) AT=920.05n

.meas tran vdout0_12ck910 FIND v(dout0_12) AT=920.05n

.meas tran vdout0_13ck910 FIND v(dout0_13) AT=920.05n

.meas tran vdout0_14ck910 FIND v(dout0_14) AT=920.05n

.meas tran vdout0_15ck910 FIND v(dout0_15) AT=920.05n

.meas tran vdout0_0ck920 FIND v(dout0_0) AT=930.05n

.meas tran vdout0_1ck920 FIND v(dout0_1) AT=930.05n

.meas tran vdout0_2ck920 FIND v(dout0_2) AT=930.05n

.meas tran vdout0_3ck920 FIND v(dout0_3) AT=930.05n

.meas tran vdout0_4ck920 FIND v(dout0_4) AT=930.05n

.meas tran vdout0_5ck920 FIND v(dout0_5) AT=930.05n

.meas tran vdout0_6ck920 FIND v(dout0_6) AT=930.05n

.meas tran vdout0_7ck920 FIND v(dout0_7) AT=930.05n

.meas tran vdout0_8ck920 FIND v(dout0_8) AT=930.05n

.meas tran vdout0_9ck920 FIND v(dout0_9) AT=930.05n

.meas tran vdout0_10ck920 FIND v(dout0_10) AT=930.05n

.meas tran vdout0_11ck920 FIND v(dout0_11) AT=930.05n

.meas tran vdout0_12ck920 FIND v(dout0_12) AT=930.05n

.meas tran vdout0_13ck920 FIND v(dout0_13) AT=930.05n

.meas tran vdout0_14ck920 FIND v(dout0_14) AT=930.05n

.meas tran vdout0_15ck920 FIND v(dout0_15) AT=930.05n

.meas tran vdout0_0ck930 FIND v(dout0_0) AT=940.05n

.meas tran vdout0_1ck930 FIND v(dout0_1) AT=940.05n

.meas tran vdout0_2ck930 FIND v(dout0_2) AT=940.05n

.meas tran vdout0_3ck930 FIND v(dout0_3) AT=940.05n

.meas tran vdout0_4ck930 FIND v(dout0_4) AT=940.05n

.meas tran vdout0_5ck930 FIND v(dout0_5) AT=940.05n

.meas tran vdout0_6ck930 FIND v(dout0_6) AT=940.05n

.meas tran vdout0_7ck930 FIND v(dout0_7) AT=940.05n

.meas tran vdout0_8ck930 FIND v(dout0_8) AT=940.05n

.meas tran vdout0_9ck930 FIND v(dout0_9) AT=940.05n

.meas tran vdout0_10ck930 FIND v(dout0_10) AT=940.05n

.meas tran vdout0_11ck930 FIND v(dout0_11) AT=940.05n

.meas tran vdout0_12ck930 FIND v(dout0_12) AT=940.05n

.meas tran vdout0_13ck930 FIND v(dout0_13) AT=940.05n

.meas tran vdout0_14ck930 FIND v(dout0_14) AT=940.05n

.meas tran vdout0_15ck930 FIND v(dout0_15) AT=940.05n

.meas tran vdout0_0ck960 FIND v(dout0_0) AT=970.05n

.meas tran vdout0_1ck960 FIND v(dout0_1) AT=970.05n

.meas tran vdout0_2ck960 FIND v(dout0_2) AT=970.05n

.meas tran vdout0_3ck960 FIND v(dout0_3) AT=970.05n

.meas tran vdout0_4ck960 FIND v(dout0_4) AT=970.05n

.meas tran vdout0_5ck960 FIND v(dout0_5) AT=970.05n

.meas tran vdout0_6ck960 FIND v(dout0_6) AT=970.05n

.meas tran vdout0_7ck960 FIND v(dout0_7) AT=970.05n

.meas tran vdout0_8ck960 FIND v(dout0_8) AT=970.05n

.meas tran vdout0_9ck960 FIND v(dout0_9) AT=970.05n

.meas tran vdout0_10ck960 FIND v(dout0_10) AT=970.05n

.meas tran vdout0_11ck960 FIND v(dout0_11) AT=970.05n

.meas tran vdout0_12ck960 FIND v(dout0_12) AT=970.05n

.meas tran vdout0_13ck960 FIND v(dout0_13) AT=970.05n

.meas tran vdout0_14ck960 FIND v(dout0_14) AT=970.05n

.meas tran vdout0_15ck960 FIND v(dout0_15) AT=970.05n

.meas tran vdout0_0ck970 FIND v(dout0_0) AT=980.05n

.meas tran vdout0_1ck970 FIND v(dout0_1) AT=980.05n

.meas tran vdout0_2ck970 FIND v(dout0_2) AT=980.05n

.meas tran vdout0_3ck970 FIND v(dout0_3) AT=980.05n

.meas tran vdout0_4ck970 FIND v(dout0_4) AT=980.05n

.meas tran vdout0_5ck970 FIND v(dout0_5) AT=980.05n

.meas tran vdout0_6ck970 FIND v(dout0_6) AT=980.05n

.meas tran vdout0_7ck970 FIND v(dout0_7) AT=980.05n

.meas tran vdout0_8ck970 FIND v(dout0_8) AT=980.05n

.meas tran vdout0_9ck970 FIND v(dout0_9) AT=980.05n

.meas tran vdout0_10ck970 FIND v(dout0_10) AT=980.05n

.meas tran vdout0_11ck970 FIND v(dout0_11) AT=980.05n

.meas tran vdout0_12ck970 FIND v(dout0_12) AT=980.05n

.meas tran vdout0_13ck970 FIND v(dout0_13) AT=980.05n

.meas tran vdout0_14ck970 FIND v(dout0_14) AT=980.05n

.meas tran vdout0_15ck970 FIND v(dout0_15) AT=980.05n

.meas tran vdout0_0ck980 FIND v(dout0_0) AT=990.05n

.meas tran vdout0_1ck980 FIND v(dout0_1) AT=990.05n

.meas tran vdout0_2ck980 FIND v(dout0_2) AT=990.05n

.meas tran vdout0_3ck980 FIND v(dout0_3) AT=990.05n

.meas tran vdout0_4ck980 FIND v(dout0_4) AT=990.05n

.meas tran vdout0_5ck980 FIND v(dout0_5) AT=990.05n

.meas tran vdout0_6ck980 FIND v(dout0_6) AT=990.05n

.meas tran vdout0_7ck980 FIND v(dout0_7) AT=990.05n

.meas tran vdout0_8ck980 FIND v(dout0_8) AT=990.05n

.meas tran vdout0_9ck980 FIND v(dout0_9) AT=990.05n

.meas tran vdout0_10ck980 FIND v(dout0_10) AT=990.05n

.meas tran vdout0_11ck980 FIND v(dout0_11) AT=990.05n

.meas tran vdout0_12ck980 FIND v(dout0_12) AT=990.05n

.meas tran vdout0_13ck980 FIND v(dout0_13) AT=990.05n

.meas tran vdout0_14ck980 FIND v(dout0_14) AT=990.05n

.meas tran vdout0_15ck980 FIND v(dout0_15) AT=990.05n

.meas tran vdout0_0ck1000 FIND v(dout0_0) AT=1010.05n

.meas tran vdout0_1ck1000 FIND v(dout0_1) AT=1010.05n

.meas tran vdout0_2ck1000 FIND v(dout0_2) AT=1010.05n

.meas tran vdout0_3ck1000 FIND v(dout0_3) AT=1010.05n

.meas tran vdout0_4ck1000 FIND v(dout0_4) AT=1010.05n

.meas tran vdout0_5ck1000 FIND v(dout0_5) AT=1010.05n

.meas tran vdout0_6ck1000 FIND v(dout0_6) AT=1010.05n

.meas tran vdout0_7ck1000 FIND v(dout0_7) AT=1010.05n

.meas tran vdout0_8ck1000 FIND v(dout0_8) AT=1010.05n

.meas tran vdout0_9ck1000 FIND v(dout0_9) AT=1010.05n

.meas tran vdout0_10ck1000 FIND v(dout0_10) AT=1010.05n

.meas tran vdout0_11ck1000 FIND v(dout0_11) AT=1010.05n

.meas tran vdout0_12ck1000 FIND v(dout0_12) AT=1010.05n

.meas tran vdout0_13ck1000 FIND v(dout0_13) AT=1010.05n

.meas tran vdout0_14ck1000 FIND v(dout0_14) AT=1010.05n

.meas tran vdout0_15ck1000 FIND v(dout0_15) AT=1010.05n

.meas tran vdout0_0ck1010 FIND v(dout0_0) AT=1020.05n

.meas tran vdout0_1ck1010 FIND v(dout0_1) AT=1020.05n

.meas tran vdout0_2ck1010 FIND v(dout0_2) AT=1020.05n

.meas tran vdout0_3ck1010 FIND v(dout0_3) AT=1020.05n

.meas tran vdout0_4ck1010 FIND v(dout0_4) AT=1020.05n

.meas tran vdout0_5ck1010 FIND v(dout0_5) AT=1020.05n

.meas tran vdout0_6ck1010 FIND v(dout0_6) AT=1020.05n

.meas tran vdout0_7ck1010 FIND v(dout0_7) AT=1020.05n

.meas tran vdout0_8ck1010 FIND v(dout0_8) AT=1020.05n

.meas tran vdout0_9ck1010 FIND v(dout0_9) AT=1020.05n

.meas tran vdout0_10ck1010 FIND v(dout0_10) AT=1020.05n

.meas tran vdout0_11ck1010 FIND v(dout0_11) AT=1020.05n

.meas tran vdout0_12ck1010 FIND v(dout0_12) AT=1020.05n

.meas tran vdout0_13ck1010 FIND v(dout0_13) AT=1020.05n

.meas tran vdout0_14ck1010 FIND v(dout0_14) AT=1020.05n

.meas tran vdout0_15ck1010 FIND v(dout0_15) AT=1020.05n

.meas tran vdout0_0ck1020 FIND v(dout0_0) AT=1030.05n

.meas tran vdout0_1ck1020 FIND v(dout0_1) AT=1030.05n

.meas tran vdout0_2ck1020 FIND v(dout0_2) AT=1030.05n

.meas tran vdout0_3ck1020 FIND v(dout0_3) AT=1030.05n

.meas tran vdout0_4ck1020 FIND v(dout0_4) AT=1030.05n

.meas tran vdout0_5ck1020 FIND v(dout0_5) AT=1030.05n

.meas tran vdout0_6ck1020 FIND v(dout0_6) AT=1030.05n

.meas tran vdout0_7ck1020 FIND v(dout0_7) AT=1030.05n

.meas tran vdout0_8ck1020 FIND v(dout0_8) AT=1030.05n

.meas tran vdout0_9ck1020 FIND v(dout0_9) AT=1030.05n

.meas tran vdout0_10ck1020 FIND v(dout0_10) AT=1030.05n

.meas tran vdout0_11ck1020 FIND v(dout0_11) AT=1030.05n

.meas tran vdout0_12ck1020 FIND v(dout0_12) AT=1030.05n

.meas tran vdout0_13ck1020 FIND v(dout0_13) AT=1030.05n

.meas tran vdout0_14ck1020 FIND v(dout0_14) AT=1030.05n

.meas tran vdout0_15ck1020 FIND v(dout0_15) AT=1030.05n

.meas tran vdout0_0ck1060 FIND v(dout0_0) AT=1070.05n

.meas tran vdout0_1ck1060 FIND v(dout0_1) AT=1070.05n

.meas tran vdout0_2ck1060 FIND v(dout0_2) AT=1070.05n

.meas tran vdout0_3ck1060 FIND v(dout0_3) AT=1070.05n

.meas tran vdout0_4ck1060 FIND v(dout0_4) AT=1070.05n

.meas tran vdout0_5ck1060 FIND v(dout0_5) AT=1070.05n

.meas tran vdout0_6ck1060 FIND v(dout0_6) AT=1070.05n

.meas tran vdout0_7ck1060 FIND v(dout0_7) AT=1070.05n

.meas tran vdout0_8ck1060 FIND v(dout0_8) AT=1070.05n

.meas tran vdout0_9ck1060 FIND v(dout0_9) AT=1070.05n

.meas tran vdout0_10ck1060 FIND v(dout0_10) AT=1070.05n

.meas tran vdout0_11ck1060 FIND v(dout0_11) AT=1070.05n

.meas tran vdout0_12ck1060 FIND v(dout0_12) AT=1070.05n

.meas tran vdout0_13ck1060 FIND v(dout0_13) AT=1070.05n

.meas tran vdout0_14ck1060 FIND v(dout0_14) AT=1070.05n

.meas tran vdout0_15ck1060 FIND v(dout0_15) AT=1070.05n

.meas tran vdout0_0ck1080 FIND v(dout0_0) AT=1090.05n

.meas tran vdout0_1ck1080 FIND v(dout0_1) AT=1090.05n

.meas tran vdout0_2ck1080 FIND v(dout0_2) AT=1090.05n

.meas tran vdout0_3ck1080 FIND v(dout0_3) AT=1090.05n

.meas tran vdout0_4ck1080 FIND v(dout0_4) AT=1090.05n

.meas tran vdout0_5ck1080 FIND v(dout0_5) AT=1090.05n

.meas tran vdout0_6ck1080 FIND v(dout0_6) AT=1090.05n

.meas tran vdout0_7ck1080 FIND v(dout0_7) AT=1090.05n

.meas tran vdout0_8ck1080 FIND v(dout0_8) AT=1090.05n

.meas tran vdout0_9ck1080 FIND v(dout0_9) AT=1090.05n

.meas tran vdout0_10ck1080 FIND v(dout0_10) AT=1090.05n

.meas tran vdout0_11ck1080 FIND v(dout0_11) AT=1090.05n

.meas tran vdout0_12ck1080 FIND v(dout0_12) AT=1090.05n

.meas tran vdout0_13ck1080 FIND v(dout0_13) AT=1090.05n

.meas tran vdout0_14ck1080 FIND v(dout0_14) AT=1090.05n

.meas tran vdout0_15ck1080 FIND v(dout0_15) AT=1090.05n

.meas tran vdout0_0ck1100 FIND v(dout0_0) AT=1110.05n

.meas tran vdout0_1ck1100 FIND v(dout0_1) AT=1110.05n

.meas tran vdout0_2ck1100 FIND v(dout0_2) AT=1110.05n

.meas tran vdout0_3ck1100 FIND v(dout0_3) AT=1110.05n

.meas tran vdout0_4ck1100 FIND v(dout0_4) AT=1110.05n

.meas tran vdout0_5ck1100 FIND v(dout0_5) AT=1110.05n

.meas tran vdout0_6ck1100 FIND v(dout0_6) AT=1110.05n

.meas tran vdout0_7ck1100 FIND v(dout0_7) AT=1110.05n

.meas tran vdout0_8ck1100 FIND v(dout0_8) AT=1110.05n

.meas tran vdout0_9ck1100 FIND v(dout0_9) AT=1110.05n

.meas tran vdout0_10ck1100 FIND v(dout0_10) AT=1110.05n

.meas tran vdout0_11ck1100 FIND v(dout0_11) AT=1110.05n

.meas tran vdout0_12ck1100 FIND v(dout0_12) AT=1110.05n

.meas tran vdout0_13ck1100 FIND v(dout0_13) AT=1110.05n

.meas tran vdout0_14ck1100 FIND v(dout0_14) AT=1110.05n

.meas tran vdout0_15ck1100 FIND v(dout0_15) AT=1110.05n

.meas tran vdout0_0ck1110 FIND v(dout0_0) AT=1120.05n

.meas tran vdout0_1ck1110 FIND v(dout0_1) AT=1120.05n

.meas tran vdout0_2ck1110 FIND v(dout0_2) AT=1120.05n

.meas tran vdout0_3ck1110 FIND v(dout0_3) AT=1120.05n

.meas tran vdout0_4ck1110 FIND v(dout0_4) AT=1120.05n

.meas tran vdout0_5ck1110 FIND v(dout0_5) AT=1120.05n

.meas tran vdout0_6ck1110 FIND v(dout0_6) AT=1120.05n

.meas tran vdout0_7ck1110 FIND v(dout0_7) AT=1120.05n

.meas tran vdout0_8ck1110 FIND v(dout0_8) AT=1120.05n

.meas tran vdout0_9ck1110 FIND v(dout0_9) AT=1120.05n

.meas tran vdout0_10ck1110 FIND v(dout0_10) AT=1120.05n

.meas tran vdout0_11ck1110 FIND v(dout0_11) AT=1120.05n

.meas tran vdout0_12ck1110 FIND v(dout0_12) AT=1120.05n

.meas tran vdout0_13ck1110 FIND v(dout0_13) AT=1120.05n

.meas tran vdout0_14ck1110 FIND v(dout0_14) AT=1120.05n

.meas tran vdout0_15ck1110 FIND v(dout0_15) AT=1120.05n

.meas tran vdout0_0ck1140 FIND v(dout0_0) AT=1150.05n

.meas tran vdout0_1ck1140 FIND v(dout0_1) AT=1150.05n

.meas tran vdout0_2ck1140 FIND v(dout0_2) AT=1150.05n

.meas tran vdout0_3ck1140 FIND v(dout0_3) AT=1150.05n

.meas tran vdout0_4ck1140 FIND v(dout0_4) AT=1150.05n

.meas tran vdout0_5ck1140 FIND v(dout0_5) AT=1150.05n

.meas tran vdout0_6ck1140 FIND v(dout0_6) AT=1150.05n

.meas tran vdout0_7ck1140 FIND v(dout0_7) AT=1150.05n

.meas tran vdout0_8ck1140 FIND v(dout0_8) AT=1150.05n

.meas tran vdout0_9ck1140 FIND v(dout0_9) AT=1150.05n

.meas tran vdout0_10ck1140 FIND v(dout0_10) AT=1150.05n

.meas tran vdout0_11ck1140 FIND v(dout0_11) AT=1150.05n

.meas tran vdout0_12ck1140 FIND v(dout0_12) AT=1150.05n

.meas tran vdout0_13ck1140 FIND v(dout0_13) AT=1150.05n

.meas tran vdout0_14ck1140 FIND v(dout0_14) AT=1150.05n

.meas tran vdout0_15ck1140 FIND v(dout0_15) AT=1150.05n

.meas tran vdout0_0ck1170 FIND v(dout0_0) AT=1180.05n

.meas tran vdout0_1ck1170 FIND v(dout0_1) AT=1180.05n

.meas tran vdout0_2ck1170 FIND v(dout0_2) AT=1180.05n

.meas tran vdout0_3ck1170 FIND v(dout0_3) AT=1180.05n

.meas tran vdout0_4ck1170 FIND v(dout0_4) AT=1180.05n

.meas tran vdout0_5ck1170 FIND v(dout0_5) AT=1180.05n

.meas tran vdout0_6ck1170 FIND v(dout0_6) AT=1180.05n

.meas tran vdout0_7ck1170 FIND v(dout0_7) AT=1180.05n

.meas tran vdout0_8ck1170 FIND v(dout0_8) AT=1180.05n

.meas tran vdout0_9ck1170 FIND v(dout0_9) AT=1180.05n

.meas tran vdout0_10ck1170 FIND v(dout0_10) AT=1180.05n

.meas tran vdout0_11ck1170 FIND v(dout0_11) AT=1180.05n

.meas tran vdout0_12ck1170 FIND v(dout0_12) AT=1180.05n

.meas tran vdout0_13ck1170 FIND v(dout0_13) AT=1180.05n

.meas tran vdout0_14ck1170 FIND v(dout0_14) AT=1180.05n

.meas tran vdout0_15ck1170 FIND v(dout0_15) AT=1180.05n

.meas tran vdout0_0ck1190 FIND v(dout0_0) AT=1200.05n

.meas tran vdout0_1ck1190 FIND v(dout0_1) AT=1200.05n

.meas tran vdout0_2ck1190 FIND v(dout0_2) AT=1200.05n

.meas tran vdout0_3ck1190 FIND v(dout0_3) AT=1200.05n

.meas tran vdout0_4ck1190 FIND v(dout0_4) AT=1200.05n

.meas tran vdout0_5ck1190 FIND v(dout0_5) AT=1200.05n

.meas tran vdout0_6ck1190 FIND v(dout0_6) AT=1200.05n

.meas tran vdout0_7ck1190 FIND v(dout0_7) AT=1200.05n

.meas tran vdout0_8ck1190 FIND v(dout0_8) AT=1200.05n

.meas tran vdout0_9ck1190 FIND v(dout0_9) AT=1200.05n

.meas tran vdout0_10ck1190 FIND v(dout0_10) AT=1200.05n

.meas tran vdout0_11ck1190 FIND v(dout0_11) AT=1200.05n

.meas tran vdout0_12ck1190 FIND v(dout0_12) AT=1200.05n

.meas tran vdout0_13ck1190 FIND v(dout0_13) AT=1200.05n

.meas tran vdout0_14ck1190 FIND v(dout0_14) AT=1200.05n

.meas tran vdout0_15ck1190 FIND v(dout0_15) AT=1200.05n

.meas tran vdout0_0ck1230 FIND v(dout0_0) AT=1240.05n

.meas tran vdout0_1ck1230 FIND v(dout0_1) AT=1240.05n

.meas tran vdout0_2ck1230 FIND v(dout0_2) AT=1240.05n

.meas tran vdout0_3ck1230 FIND v(dout0_3) AT=1240.05n

.meas tran vdout0_4ck1230 FIND v(dout0_4) AT=1240.05n

.meas tran vdout0_5ck1230 FIND v(dout0_5) AT=1240.05n

.meas tran vdout0_6ck1230 FIND v(dout0_6) AT=1240.05n

.meas tran vdout0_7ck1230 FIND v(dout0_7) AT=1240.05n

.meas tran vdout0_8ck1230 FIND v(dout0_8) AT=1240.05n

.meas tran vdout0_9ck1230 FIND v(dout0_9) AT=1240.05n

.meas tran vdout0_10ck1230 FIND v(dout0_10) AT=1240.05n

.meas tran vdout0_11ck1230 FIND v(dout0_11) AT=1240.05n

.meas tran vdout0_12ck1230 FIND v(dout0_12) AT=1240.05n

.meas tran vdout0_13ck1230 FIND v(dout0_13) AT=1240.05n

.meas tran vdout0_14ck1230 FIND v(dout0_14) AT=1240.05n

.meas tran vdout0_15ck1230 FIND v(dout0_15) AT=1240.05n

.meas tran vdout0_0ck1250 FIND v(dout0_0) AT=1260.05n

.meas tran vdout0_1ck1250 FIND v(dout0_1) AT=1260.05n

.meas tran vdout0_2ck1250 FIND v(dout0_2) AT=1260.05n

.meas tran vdout0_3ck1250 FIND v(dout0_3) AT=1260.05n

.meas tran vdout0_4ck1250 FIND v(dout0_4) AT=1260.05n

.meas tran vdout0_5ck1250 FIND v(dout0_5) AT=1260.05n

.meas tran vdout0_6ck1250 FIND v(dout0_6) AT=1260.05n

.meas tran vdout0_7ck1250 FIND v(dout0_7) AT=1260.05n

.meas tran vdout0_8ck1250 FIND v(dout0_8) AT=1260.05n

.meas tran vdout0_9ck1250 FIND v(dout0_9) AT=1260.05n

.meas tran vdout0_10ck1250 FIND v(dout0_10) AT=1260.05n

.meas tran vdout0_11ck1250 FIND v(dout0_11) AT=1260.05n

.meas tran vdout0_12ck1250 FIND v(dout0_12) AT=1260.05n

.meas tran vdout0_13ck1250 FIND v(dout0_13) AT=1260.05n

.meas tran vdout0_14ck1250 FIND v(dout0_14) AT=1260.05n

.meas tran vdout0_15ck1250 FIND v(dout0_15) AT=1260.05n

.meas tran vdout0_0ck1260 FIND v(dout0_0) AT=1270.05n

.meas tran vdout0_1ck1260 FIND v(dout0_1) AT=1270.05n

.meas tran vdout0_2ck1260 FIND v(dout0_2) AT=1270.05n

.meas tran vdout0_3ck1260 FIND v(dout0_3) AT=1270.05n

.meas tran vdout0_4ck1260 FIND v(dout0_4) AT=1270.05n

.meas tran vdout0_5ck1260 FIND v(dout0_5) AT=1270.05n

.meas tran vdout0_6ck1260 FIND v(dout0_6) AT=1270.05n

.meas tran vdout0_7ck1260 FIND v(dout0_7) AT=1270.05n

.meas tran vdout0_8ck1260 FIND v(dout0_8) AT=1270.05n

.meas tran vdout0_9ck1260 FIND v(dout0_9) AT=1270.05n

.meas tran vdout0_10ck1260 FIND v(dout0_10) AT=1270.05n

.meas tran vdout0_11ck1260 FIND v(dout0_11) AT=1270.05n

.meas tran vdout0_12ck1260 FIND v(dout0_12) AT=1270.05n

.meas tran vdout0_13ck1260 FIND v(dout0_13) AT=1270.05n

.meas tran vdout0_14ck1260 FIND v(dout0_14) AT=1270.05n

.meas tran vdout0_15ck1260 FIND v(dout0_15) AT=1270.05n

.meas tran vdout0_0ck1300 FIND v(dout0_0) AT=1310.05n

.meas tran vdout0_1ck1300 FIND v(dout0_1) AT=1310.05n

.meas tran vdout0_2ck1300 FIND v(dout0_2) AT=1310.05n

.meas tran vdout0_3ck1300 FIND v(dout0_3) AT=1310.05n

.meas tran vdout0_4ck1300 FIND v(dout0_4) AT=1310.05n

.meas tran vdout0_5ck1300 FIND v(dout0_5) AT=1310.05n

.meas tran vdout0_6ck1300 FIND v(dout0_6) AT=1310.05n

.meas tran vdout0_7ck1300 FIND v(dout0_7) AT=1310.05n

.meas tran vdout0_8ck1300 FIND v(dout0_8) AT=1310.05n

.meas tran vdout0_9ck1300 FIND v(dout0_9) AT=1310.05n

.meas tran vdout0_10ck1300 FIND v(dout0_10) AT=1310.05n

.meas tran vdout0_11ck1300 FIND v(dout0_11) AT=1310.05n

.meas tran vdout0_12ck1300 FIND v(dout0_12) AT=1310.05n

.meas tran vdout0_13ck1300 FIND v(dout0_13) AT=1310.05n

.meas tran vdout0_14ck1300 FIND v(dout0_14) AT=1310.05n

.meas tran vdout0_15ck1300 FIND v(dout0_15) AT=1310.05n

.meas tran vdout0_0ck1310 FIND v(dout0_0) AT=1320.05n

.meas tran vdout0_1ck1310 FIND v(dout0_1) AT=1320.05n

.meas tran vdout0_2ck1310 FIND v(dout0_2) AT=1320.05n

.meas tran vdout0_3ck1310 FIND v(dout0_3) AT=1320.05n

.meas tran vdout0_4ck1310 FIND v(dout0_4) AT=1320.05n

.meas tran vdout0_5ck1310 FIND v(dout0_5) AT=1320.05n

.meas tran vdout0_6ck1310 FIND v(dout0_6) AT=1320.05n

.meas tran vdout0_7ck1310 FIND v(dout0_7) AT=1320.05n

.meas tran vdout0_8ck1310 FIND v(dout0_8) AT=1320.05n

.meas tran vdout0_9ck1310 FIND v(dout0_9) AT=1320.05n

.meas tran vdout0_10ck1310 FIND v(dout0_10) AT=1320.05n

.meas tran vdout0_11ck1310 FIND v(dout0_11) AT=1320.05n

.meas tran vdout0_12ck1310 FIND v(dout0_12) AT=1320.05n

.meas tran vdout0_13ck1310 FIND v(dout0_13) AT=1320.05n

.meas tran vdout0_14ck1310 FIND v(dout0_14) AT=1320.05n

.meas tran vdout0_15ck1310 FIND v(dout0_15) AT=1320.05n

.meas tran vdout0_0ck1330 FIND v(dout0_0) AT=1340.05n

.meas tran vdout0_1ck1330 FIND v(dout0_1) AT=1340.05n

.meas tran vdout0_2ck1330 FIND v(dout0_2) AT=1340.05n

.meas tran vdout0_3ck1330 FIND v(dout0_3) AT=1340.05n

.meas tran vdout0_4ck1330 FIND v(dout0_4) AT=1340.05n

.meas tran vdout0_5ck1330 FIND v(dout0_5) AT=1340.05n

.meas tran vdout0_6ck1330 FIND v(dout0_6) AT=1340.05n

.meas tran vdout0_7ck1330 FIND v(dout0_7) AT=1340.05n

.meas tran vdout0_8ck1330 FIND v(dout0_8) AT=1340.05n

.meas tran vdout0_9ck1330 FIND v(dout0_9) AT=1340.05n

.meas tran vdout0_10ck1330 FIND v(dout0_10) AT=1340.05n

.meas tran vdout0_11ck1330 FIND v(dout0_11) AT=1340.05n

.meas tran vdout0_12ck1330 FIND v(dout0_12) AT=1340.05n

.meas tran vdout0_13ck1330 FIND v(dout0_13) AT=1340.05n

.meas tran vdout0_14ck1330 FIND v(dout0_14) AT=1340.05n

.meas tran vdout0_15ck1330 FIND v(dout0_15) AT=1340.05n

.meas tran vdout0_0ck1350 FIND v(dout0_0) AT=1360.05n

.meas tran vdout0_1ck1350 FIND v(dout0_1) AT=1360.05n

.meas tran vdout0_2ck1350 FIND v(dout0_2) AT=1360.05n

.meas tran vdout0_3ck1350 FIND v(dout0_3) AT=1360.05n

.meas tran vdout0_4ck1350 FIND v(dout0_4) AT=1360.05n

.meas tran vdout0_5ck1350 FIND v(dout0_5) AT=1360.05n

.meas tran vdout0_6ck1350 FIND v(dout0_6) AT=1360.05n

.meas tran vdout0_7ck1350 FIND v(dout0_7) AT=1360.05n

.meas tran vdout0_8ck1350 FIND v(dout0_8) AT=1360.05n

.meas tran vdout0_9ck1350 FIND v(dout0_9) AT=1360.05n

.meas tran vdout0_10ck1350 FIND v(dout0_10) AT=1360.05n

.meas tran vdout0_11ck1350 FIND v(dout0_11) AT=1360.05n

.meas tran vdout0_12ck1350 FIND v(dout0_12) AT=1360.05n

.meas tran vdout0_13ck1350 FIND v(dout0_13) AT=1360.05n

.meas tran vdout0_14ck1350 FIND v(dout0_14) AT=1360.05n

.meas tran vdout0_15ck1350 FIND v(dout0_15) AT=1360.05n

.meas tran vdout0_0ck1380 FIND v(dout0_0) AT=1390.05n

.meas tran vdout0_1ck1380 FIND v(dout0_1) AT=1390.05n

.meas tran vdout0_2ck1380 FIND v(dout0_2) AT=1390.05n

.meas tran vdout0_3ck1380 FIND v(dout0_3) AT=1390.05n

.meas tran vdout0_4ck1380 FIND v(dout0_4) AT=1390.05n

.meas tran vdout0_5ck1380 FIND v(dout0_5) AT=1390.05n

.meas tran vdout0_6ck1380 FIND v(dout0_6) AT=1390.05n

.meas tran vdout0_7ck1380 FIND v(dout0_7) AT=1390.05n

.meas tran vdout0_8ck1380 FIND v(dout0_8) AT=1390.05n

.meas tran vdout0_9ck1380 FIND v(dout0_9) AT=1390.05n

.meas tran vdout0_10ck1380 FIND v(dout0_10) AT=1390.05n

.meas tran vdout0_11ck1380 FIND v(dout0_11) AT=1390.05n

.meas tran vdout0_12ck1380 FIND v(dout0_12) AT=1390.05n

.meas tran vdout0_13ck1380 FIND v(dout0_13) AT=1390.05n

.meas tran vdout0_14ck1380 FIND v(dout0_14) AT=1390.05n

.meas tran vdout0_15ck1380 FIND v(dout0_15) AT=1390.05n

.meas tran vdout0_0ck1410 FIND v(dout0_0) AT=1420.05n

.meas tran vdout0_1ck1410 FIND v(dout0_1) AT=1420.05n

.meas tran vdout0_2ck1410 FIND v(dout0_2) AT=1420.05n

.meas tran vdout0_3ck1410 FIND v(dout0_3) AT=1420.05n

.meas tran vdout0_4ck1410 FIND v(dout0_4) AT=1420.05n

.meas tran vdout0_5ck1410 FIND v(dout0_5) AT=1420.05n

.meas tran vdout0_6ck1410 FIND v(dout0_6) AT=1420.05n

.meas tran vdout0_7ck1410 FIND v(dout0_7) AT=1420.05n

.meas tran vdout0_8ck1410 FIND v(dout0_8) AT=1420.05n

.meas tran vdout0_9ck1410 FIND v(dout0_9) AT=1420.05n

.meas tran vdout0_10ck1410 FIND v(dout0_10) AT=1420.05n

.meas tran vdout0_11ck1410 FIND v(dout0_11) AT=1420.05n

.meas tran vdout0_12ck1410 FIND v(dout0_12) AT=1420.05n

.meas tran vdout0_13ck1410 FIND v(dout0_13) AT=1420.05n

.meas tran vdout0_14ck1410 FIND v(dout0_14) AT=1420.05n

.meas tran vdout0_15ck1410 FIND v(dout0_15) AT=1420.05n

.meas tran vdout0_0ck1430 FIND v(dout0_0) AT=1440.05n

.meas tran vdout0_1ck1430 FIND v(dout0_1) AT=1440.05n

.meas tran vdout0_2ck1430 FIND v(dout0_2) AT=1440.05n

.meas tran vdout0_3ck1430 FIND v(dout0_3) AT=1440.05n

.meas tran vdout0_4ck1430 FIND v(dout0_4) AT=1440.05n

.meas tran vdout0_5ck1430 FIND v(dout0_5) AT=1440.05n

.meas tran vdout0_6ck1430 FIND v(dout0_6) AT=1440.05n

.meas tran vdout0_7ck1430 FIND v(dout0_7) AT=1440.05n

.meas tran vdout0_8ck1430 FIND v(dout0_8) AT=1440.05n

.meas tran vdout0_9ck1430 FIND v(dout0_9) AT=1440.05n

.meas tran vdout0_10ck1430 FIND v(dout0_10) AT=1440.05n

.meas tran vdout0_11ck1430 FIND v(dout0_11) AT=1440.05n

.meas tran vdout0_12ck1430 FIND v(dout0_12) AT=1440.05n

.meas tran vdout0_13ck1430 FIND v(dout0_13) AT=1440.05n

.meas tran vdout0_14ck1430 FIND v(dout0_14) AT=1440.05n

.meas tran vdout0_15ck1430 FIND v(dout0_15) AT=1440.05n

.meas tran vdout0_0ck1440 FIND v(dout0_0) AT=1450.05n

.meas tran vdout0_1ck1440 FIND v(dout0_1) AT=1450.05n

.meas tran vdout0_2ck1440 FIND v(dout0_2) AT=1450.05n

.meas tran vdout0_3ck1440 FIND v(dout0_3) AT=1450.05n

.meas tran vdout0_4ck1440 FIND v(dout0_4) AT=1450.05n

.meas tran vdout0_5ck1440 FIND v(dout0_5) AT=1450.05n

.meas tran vdout0_6ck1440 FIND v(dout0_6) AT=1450.05n

.meas tran vdout0_7ck1440 FIND v(dout0_7) AT=1450.05n

.meas tran vdout0_8ck1440 FIND v(dout0_8) AT=1450.05n

.meas tran vdout0_9ck1440 FIND v(dout0_9) AT=1450.05n

.meas tran vdout0_10ck1440 FIND v(dout0_10) AT=1450.05n

.meas tran vdout0_11ck1440 FIND v(dout0_11) AT=1450.05n

.meas tran vdout0_12ck1440 FIND v(dout0_12) AT=1450.05n

.meas tran vdout0_13ck1440 FIND v(dout0_13) AT=1450.05n

.meas tran vdout0_14ck1440 FIND v(dout0_14) AT=1450.05n

.meas tran vdout0_15ck1440 FIND v(dout0_15) AT=1450.05n

.meas tran vdout0_0ck1450 FIND v(dout0_0) AT=1460.05n

.meas tran vdout0_1ck1450 FIND v(dout0_1) AT=1460.05n

.meas tran vdout0_2ck1450 FIND v(dout0_2) AT=1460.05n

.meas tran vdout0_3ck1450 FIND v(dout0_3) AT=1460.05n

.meas tran vdout0_4ck1450 FIND v(dout0_4) AT=1460.05n

.meas tran vdout0_5ck1450 FIND v(dout0_5) AT=1460.05n

.meas tran vdout0_6ck1450 FIND v(dout0_6) AT=1460.05n

.meas tran vdout0_7ck1450 FIND v(dout0_7) AT=1460.05n

.meas tran vdout0_8ck1450 FIND v(dout0_8) AT=1460.05n

.meas tran vdout0_9ck1450 FIND v(dout0_9) AT=1460.05n

.meas tran vdout0_10ck1450 FIND v(dout0_10) AT=1460.05n

.meas tran vdout0_11ck1450 FIND v(dout0_11) AT=1460.05n

.meas tran vdout0_12ck1450 FIND v(dout0_12) AT=1460.05n

.meas tran vdout0_13ck1450 FIND v(dout0_13) AT=1460.05n

.meas tran vdout0_14ck1450 FIND v(dout0_14) AT=1460.05n

.meas tran vdout0_15ck1450 FIND v(dout0_15) AT=1460.05n

.meas tran vdout0_0ck1470 FIND v(dout0_0) AT=1480.05n

.meas tran vdout0_1ck1470 FIND v(dout0_1) AT=1480.05n

.meas tran vdout0_2ck1470 FIND v(dout0_2) AT=1480.05n

.meas tran vdout0_3ck1470 FIND v(dout0_3) AT=1480.05n

.meas tran vdout0_4ck1470 FIND v(dout0_4) AT=1480.05n

.meas tran vdout0_5ck1470 FIND v(dout0_5) AT=1480.05n

.meas tran vdout0_6ck1470 FIND v(dout0_6) AT=1480.05n

.meas tran vdout0_7ck1470 FIND v(dout0_7) AT=1480.05n

.meas tran vdout0_8ck1470 FIND v(dout0_8) AT=1480.05n

.meas tran vdout0_9ck1470 FIND v(dout0_9) AT=1480.05n

.meas tran vdout0_10ck1470 FIND v(dout0_10) AT=1480.05n

.meas tran vdout0_11ck1470 FIND v(dout0_11) AT=1480.05n

.meas tran vdout0_12ck1470 FIND v(dout0_12) AT=1480.05n

.meas tran vdout0_13ck1470 FIND v(dout0_13) AT=1480.05n

.meas tran vdout0_14ck1470 FIND v(dout0_14) AT=1480.05n

.meas tran vdout0_15ck1470 FIND v(dout0_15) AT=1480.05n

.meas tran vdout0_0ck1480 FIND v(dout0_0) AT=1490.05n

.meas tran vdout0_1ck1480 FIND v(dout0_1) AT=1490.05n

.meas tran vdout0_2ck1480 FIND v(dout0_2) AT=1490.05n

.meas tran vdout0_3ck1480 FIND v(dout0_3) AT=1490.05n

.meas tran vdout0_4ck1480 FIND v(dout0_4) AT=1490.05n

.meas tran vdout0_5ck1480 FIND v(dout0_5) AT=1490.05n

.meas tran vdout0_6ck1480 FIND v(dout0_6) AT=1490.05n

.meas tran vdout0_7ck1480 FIND v(dout0_7) AT=1490.05n

.meas tran vdout0_8ck1480 FIND v(dout0_8) AT=1490.05n

.meas tran vdout0_9ck1480 FIND v(dout0_9) AT=1490.05n

.meas tran vdout0_10ck1480 FIND v(dout0_10) AT=1490.05n

.meas tran vdout0_11ck1480 FIND v(dout0_11) AT=1490.05n

.meas tran vdout0_12ck1480 FIND v(dout0_12) AT=1490.05n

.meas tran vdout0_13ck1480 FIND v(dout0_13) AT=1490.05n

.meas tran vdout0_14ck1480 FIND v(dout0_14) AT=1490.05n

.meas tran vdout0_15ck1480 FIND v(dout0_15) AT=1490.05n

.meas tran vdout0_0ck1500 FIND v(dout0_0) AT=1510.05n

.meas tran vdout0_1ck1500 FIND v(dout0_1) AT=1510.05n

.meas tran vdout0_2ck1500 FIND v(dout0_2) AT=1510.05n

.meas tran vdout0_3ck1500 FIND v(dout0_3) AT=1510.05n

.meas tran vdout0_4ck1500 FIND v(dout0_4) AT=1510.05n

.meas tran vdout0_5ck1500 FIND v(dout0_5) AT=1510.05n

.meas tran vdout0_6ck1500 FIND v(dout0_6) AT=1510.05n

.meas tran vdout0_7ck1500 FIND v(dout0_7) AT=1510.05n

.meas tran vdout0_8ck1500 FIND v(dout0_8) AT=1510.05n

.meas tran vdout0_9ck1500 FIND v(dout0_9) AT=1510.05n

.meas tran vdout0_10ck1500 FIND v(dout0_10) AT=1510.05n

.meas tran vdout0_11ck1500 FIND v(dout0_11) AT=1510.05n

.meas tran vdout0_12ck1500 FIND v(dout0_12) AT=1510.05n

.meas tran vdout0_13ck1500 FIND v(dout0_13) AT=1510.05n

.meas tran vdout0_14ck1500 FIND v(dout0_14) AT=1510.05n

.meas tran vdout0_15ck1500 FIND v(dout0_15) AT=1510.05n

.meas tran vdout0_0ck1510 FIND v(dout0_0) AT=1520.05n

.meas tran vdout0_1ck1510 FIND v(dout0_1) AT=1520.05n

.meas tran vdout0_2ck1510 FIND v(dout0_2) AT=1520.05n

.meas tran vdout0_3ck1510 FIND v(dout0_3) AT=1520.05n

.meas tran vdout0_4ck1510 FIND v(dout0_4) AT=1520.05n

.meas tran vdout0_5ck1510 FIND v(dout0_5) AT=1520.05n

.meas tran vdout0_6ck1510 FIND v(dout0_6) AT=1520.05n

.meas tran vdout0_7ck1510 FIND v(dout0_7) AT=1520.05n

.meas tran vdout0_8ck1510 FIND v(dout0_8) AT=1520.05n

.meas tran vdout0_9ck1510 FIND v(dout0_9) AT=1520.05n

.meas tran vdout0_10ck1510 FIND v(dout0_10) AT=1520.05n

.meas tran vdout0_11ck1510 FIND v(dout0_11) AT=1520.05n

.meas tran vdout0_12ck1510 FIND v(dout0_12) AT=1520.05n

.meas tran vdout0_13ck1510 FIND v(dout0_13) AT=1520.05n

.meas tran vdout0_14ck1510 FIND v(dout0_14) AT=1520.05n

.meas tran vdout0_15ck1510 FIND v(dout0_15) AT=1520.05n

.meas tran vdout0_0ck1520 FIND v(dout0_0) AT=1530.05n

.meas tran vdout0_1ck1520 FIND v(dout0_1) AT=1530.05n

.meas tran vdout0_2ck1520 FIND v(dout0_2) AT=1530.05n

.meas tran vdout0_3ck1520 FIND v(dout0_3) AT=1530.05n

.meas tran vdout0_4ck1520 FIND v(dout0_4) AT=1530.05n

.meas tran vdout0_5ck1520 FIND v(dout0_5) AT=1530.05n

.meas tran vdout0_6ck1520 FIND v(dout0_6) AT=1530.05n

.meas tran vdout0_7ck1520 FIND v(dout0_7) AT=1530.05n

.meas tran vdout0_8ck1520 FIND v(dout0_8) AT=1530.05n

.meas tran vdout0_9ck1520 FIND v(dout0_9) AT=1530.05n

.meas tran vdout0_10ck1520 FIND v(dout0_10) AT=1530.05n

.meas tran vdout0_11ck1520 FIND v(dout0_11) AT=1530.05n

.meas tran vdout0_12ck1520 FIND v(dout0_12) AT=1530.05n

.meas tran vdout0_13ck1520 FIND v(dout0_13) AT=1530.05n

.meas tran vdout0_14ck1520 FIND v(dout0_14) AT=1530.05n

.meas tran vdout0_15ck1520 FIND v(dout0_15) AT=1530.05n

.meas tran vdout0_0ck1550 FIND v(dout0_0) AT=1560.05n

.meas tran vdout0_1ck1550 FIND v(dout0_1) AT=1560.05n

.meas tran vdout0_2ck1550 FIND v(dout0_2) AT=1560.05n

.meas tran vdout0_3ck1550 FIND v(dout0_3) AT=1560.05n

.meas tran vdout0_4ck1550 FIND v(dout0_4) AT=1560.05n

.meas tran vdout0_5ck1550 FIND v(dout0_5) AT=1560.05n

.meas tran vdout0_6ck1550 FIND v(dout0_6) AT=1560.05n

.meas tran vdout0_7ck1550 FIND v(dout0_7) AT=1560.05n

.meas tran vdout0_8ck1550 FIND v(dout0_8) AT=1560.05n

.meas tran vdout0_9ck1550 FIND v(dout0_9) AT=1560.05n

.meas tran vdout0_10ck1550 FIND v(dout0_10) AT=1560.05n

.meas tran vdout0_11ck1550 FIND v(dout0_11) AT=1560.05n

.meas tran vdout0_12ck1550 FIND v(dout0_12) AT=1560.05n

.meas tran vdout0_13ck1550 FIND v(dout0_13) AT=1560.05n

.meas tran vdout0_14ck1550 FIND v(dout0_14) AT=1560.05n

.meas tran vdout0_15ck1550 FIND v(dout0_15) AT=1560.05n

.meas tran vdout0_0ck1560 FIND v(dout0_0) AT=1570.05n

.meas tran vdout0_1ck1560 FIND v(dout0_1) AT=1570.05n

.meas tran vdout0_2ck1560 FIND v(dout0_2) AT=1570.05n

.meas tran vdout0_3ck1560 FIND v(dout0_3) AT=1570.05n

.meas tran vdout0_4ck1560 FIND v(dout0_4) AT=1570.05n

.meas tran vdout0_5ck1560 FIND v(dout0_5) AT=1570.05n

.meas tran vdout0_6ck1560 FIND v(dout0_6) AT=1570.05n

.meas tran vdout0_7ck1560 FIND v(dout0_7) AT=1570.05n

.meas tran vdout0_8ck1560 FIND v(dout0_8) AT=1570.05n

.meas tran vdout0_9ck1560 FIND v(dout0_9) AT=1570.05n

.meas tran vdout0_10ck1560 FIND v(dout0_10) AT=1570.05n

.meas tran vdout0_11ck1560 FIND v(dout0_11) AT=1570.05n

.meas tran vdout0_12ck1560 FIND v(dout0_12) AT=1570.05n

.meas tran vdout0_13ck1560 FIND v(dout0_13) AT=1570.05n

.meas tran vdout0_14ck1560 FIND v(dout0_14) AT=1570.05n

.meas tran vdout0_15ck1560 FIND v(dout0_15) AT=1570.05n

.meas tran vdout0_0ck1580 FIND v(dout0_0) AT=1590.05n

.meas tran vdout0_1ck1580 FIND v(dout0_1) AT=1590.05n

.meas tran vdout0_2ck1580 FIND v(dout0_2) AT=1590.05n

.meas tran vdout0_3ck1580 FIND v(dout0_3) AT=1590.05n

.meas tran vdout0_4ck1580 FIND v(dout0_4) AT=1590.05n

.meas tran vdout0_5ck1580 FIND v(dout0_5) AT=1590.05n

.meas tran vdout0_6ck1580 FIND v(dout0_6) AT=1590.05n

.meas tran vdout0_7ck1580 FIND v(dout0_7) AT=1590.05n

.meas tran vdout0_8ck1580 FIND v(dout0_8) AT=1590.05n

.meas tran vdout0_9ck1580 FIND v(dout0_9) AT=1590.05n

.meas tran vdout0_10ck1580 FIND v(dout0_10) AT=1590.05n

.meas tran vdout0_11ck1580 FIND v(dout0_11) AT=1590.05n

.meas tran vdout0_12ck1580 FIND v(dout0_12) AT=1590.05n

.meas tran vdout0_13ck1580 FIND v(dout0_13) AT=1590.05n

.meas tran vdout0_14ck1580 FIND v(dout0_14) AT=1590.05n

.meas tran vdout0_15ck1580 FIND v(dout0_15) AT=1590.05n

.meas tran vdout0_0ck1590 FIND v(dout0_0) AT=1600.05n

.meas tran vdout0_1ck1590 FIND v(dout0_1) AT=1600.05n

.meas tran vdout0_2ck1590 FIND v(dout0_2) AT=1600.05n

.meas tran vdout0_3ck1590 FIND v(dout0_3) AT=1600.05n

.meas tran vdout0_4ck1590 FIND v(dout0_4) AT=1600.05n

.meas tran vdout0_5ck1590 FIND v(dout0_5) AT=1600.05n

.meas tran vdout0_6ck1590 FIND v(dout0_6) AT=1600.05n

.meas tran vdout0_7ck1590 FIND v(dout0_7) AT=1600.05n

.meas tran vdout0_8ck1590 FIND v(dout0_8) AT=1600.05n

.meas tran vdout0_9ck1590 FIND v(dout0_9) AT=1600.05n

.meas tran vdout0_10ck1590 FIND v(dout0_10) AT=1600.05n

.meas tran vdout0_11ck1590 FIND v(dout0_11) AT=1600.05n

.meas tran vdout0_12ck1590 FIND v(dout0_12) AT=1600.05n

.meas tran vdout0_13ck1590 FIND v(dout0_13) AT=1600.05n

.meas tran vdout0_14ck1590 FIND v(dout0_14) AT=1600.05n

.meas tran vdout0_15ck1590 FIND v(dout0_15) AT=1600.05n

.meas tran vdout0_0ck1600 FIND v(dout0_0) AT=1610.05n

.meas tran vdout0_1ck1600 FIND v(dout0_1) AT=1610.05n

.meas tran vdout0_2ck1600 FIND v(dout0_2) AT=1610.05n

.meas tran vdout0_3ck1600 FIND v(dout0_3) AT=1610.05n

.meas tran vdout0_4ck1600 FIND v(dout0_4) AT=1610.05n

.meas tran vdout0_5ck1600 FIND v(dout0_5) AT=1610.05n

.meas tran vdout0_6ck1600 FIND v(dout0_6) AT=1610.05n

.meas tran vdout0_7ck1600 FIND v(dout0_7) AT=1610.05n

.meas tran vdout0_8ck1600 FIND v(dout0_8) AT=1610.05n

.meas tran vdout0_9ck1600 FIND v(dout0_9) AT=1610.05n

.meas tran vdout0_10ck1600 FIND v(dout0_10) AT=1610.05n

.meas tran vdout0_11ck1600 FIND v(dout0_11) AT=1610.05n

.meas tran vdout0_12ck1600 FIND v(dout0_12) AT=1610.05n

.meas tran vdout0_13ck1600 FIND v(dout0_13) AT=1610.05n

.meas tran vdout0_14ck1600 FIND v(dout0_14) AT=1610.05n

.meas tran vdout0_15ck1600 FIND v(dout0_15) AT=1610.05n

.meas tran vdout0_0ck1630 FIND v(dout0_0) AT=1640.05n

.meas tran vdout0_1ck1630 FIND v(dout0_1) AT=1640.05n

.meas tran vdout0_2ck1630 FIND v(dout0_2) AT=1640.05n

.meas tran vdout0_3ck1630 FIND v(dout0_3) AT=1640.05n

.meas tran vdout0_4ck1630 FIND v(dout0_4) AT=1640.05n

.meas tran vdout0_5ck1630 FIND v(dout0_5) AT=1640.05n

.meas tran vdout0_6ck1630 FIND v(dout0_6) AT=1640.05n

.meas tran vdout0_7ck1630 FIND v(dout0_7) AT=1640.05n

.meas tran vdout0_8ck1630 FIND v(dout0_8) AT=1640.05n

.meas tran vdout0_9ck1630 FIND v(dout0_9) AT=1640.05n

.meas tran vdout0_10ck1630 FIND v(dout0_10) AT=1640.05n

.meas tran vdout0_11ck1630 FIND v(dout0_11) AT=1640.05n

.meas tran vdout0_12ck1630 FIND v(dout0_12) AT=1640.05n

.meas tran vdout0_13ck1630 FIND v(dout0_13) AT=1640.05n

.meas tran vdout0_14ck1630 FIND v(dout0_14) AT=1640.05n

.meas tran vdout0_15ck1630 FIND v(dout0_15) AT=1640.05n

.meas tran vdout0_0ck1640 FIND v(dout0_0) AT=1650.05n

.meas tran vdout0_1ck1640 FIND v(dout0_1) AT=1650.05n

.meas tran vdout0_2ck1640 FIND v(dout0_2) AT=1650.05n

.meas tran vdout0_3ck1640 FIND v(dout0_3) AT=1650.05n

.meas tran vdout0_4ck1640 FIND v(dout0_4) AT=1650.05n

.meas tran vdout0_5ck1640 FIND v(dout0_5) AT=1650.05n

.meas tran vdout0_6ck1640 FIND v(dout0_6) AT=1650.05n

.meas tran vdout0_7ck1640 FIND v(dout0_7) AT=1650.05n

.meas tran vdout0_8ck1640 FIND v(dout0_8) AT=1650.05n

.meas tran vdout0_9ck1640 FIND v(dout0_9) AT=1650.05n

.meas tran vdout0_10ck1640 FIND v(dout0_10) AT=1650.05n

.meas tran vdout0_11ck1640 FIND v(dout0_11) AT=1650.05n

.meas tran vdout0_12ck1640 FIND v(dout0_12) AT=1650.05n

.meas tran vdout0_13ck1640 FIND v(dout0_13) AT=1650.05n

.meas tran vdout0_14ck1640 FIND v(dout0_14) AT=1650.05n

.meas tran vdout0_15ck1640 FIND v(dout0_15) AT=1650.05n

.meas tran vdout0_0ck1680 FIND v(dout0_0) AT=1690.05n

.meas tran vdout0_1ck1680 FIND v(dout0_1) AT=1690.05n

.meas tran vdout0_2ck1680 FIND v(dout0_2) AT=1690.05n

.meas tran vdout0_3ck1680 FIND v(dout0_3) AT=1690.05n

.meas tran vdout0_4ck1680 FIND v(dout0_4) AT=1690.05n

.meas tran vdout0_5ck1680 FIND v(dout0_5) AT=1690.05n

.meas tran vdout0_6ck1680 FIND v(dout0_6) AT=1690.05n

.meas tran vdout0_7ck1680 FIND v(dout0_7) AT=1690.05n

.meas tran vdout0_8ck1680 FIND v(dout0_8) AT=1690.05n

.meas tran vdout0_9ck1680 FIND v(dout0_9) AT=1690.05n

.meas tran vdout0_10ck1680 FIND v(dout0_10) AT=1690.05n

.meas tran vdout0_11ck1680 FIND v(dout0_11) AT=1690.05n

.meas tran vdout0_12ck1680 FIND v(dout0_12) AT=1690.05n

.meas tran vdout0_13ck1680 FIND v(dout0_13) AT=1690.05n

.meas tran vdout0_14ck1680 FIND v(dout0_14) AT=1690.05n

.meas tran vdout0_15ck1680 FIND v(dout0_15) AT=1690.05n

.meas tran vdout0_0ck1700 FIND v(dout0_0) AT=1710.05n

.meas tran vdout0_1ck1700 FIND v(dout0_1) AT=1710.05n

.meas tran vdout0_2ck1700 FIND v(dout0_2) AT=1710.05n

.meas tran vdout0_3ck1700 FIND v(dout0_3) AT=1710.05n

.meas tran vdout0_4ck1700 FIND v(dout0_4) AT=1710.05n

.meas tran vdout0_5ck1700 FIND v(dout0_5) AT=1710.05n

.meas tran vdout0_6ck1700 FIND v(dout0_6) AT=1710.05n

.meas tran vdout0_7ck1700 FIND v(dout0_7) AT=1710.05n

.meas tran vdout0_8ck1700 FIND v(dout0_8) AT=1710.05n

.meas tran vdout0_9ck1700 FIND v(dout0_9) AT=1710.05n

.meas tran vdout0_10ck1700 FIND v(dout0_10) AT=1710.05n

.meas tran vdout0_11ck1700 FIND v(dout0_11) AT=1710.05n

.meas tran vdout0_12ck1700 FIND v(dout0_12) AT=1710.05n

.meas tran vdout0_13ck1700 FIND v(dout0_13) AT=1710.05n

.meas tran vdout0_14ck1700 FIND v(dout0_14) AT=1710.05n

.meas tran vdout0_15ck1700 FIND v(dout0_15) AT=1710.05n

.meas tran vdout0_0ck1710 FIND v(dout0_0) AT=1720.05n

.meas tran vdout0_1ck1710 FIND v(dout0_1) AT=1720.05n

.meas tran vdout0_2ck1710 FIND v(dout0_2) AT=1720.05n

.meas tran vdout0_3ck1710 FIND v(dout0_3) AT=1720.05n

.meas tran vdout0_4ck1710 FIND v(dout0_4) AT=1720.05n

.meas tran vdout0_5ck1710 FIND v(dout0_5) AT=1720.05n

.meas tran vdout0_6ck1710 FIND v(dout0_6) AT=1720.05n

.meas tran vdout0_7ck1710 FIND v(dout0_7) AT=1720.05n

.meas tran vdout0_8ck1710 FIND v(dout0_8) AT=1720.05n

.meas tran vdout0_9ck1710 FIND v(dout0_9) AT=1720.05n

.meas tran vdout0_10ck1710 FIND v(dout0_10) AT=1720.05n

.meas tran vdout0_11ck1710 FIND v(dout0_11) AT=1720.05n

.meas tran vdout0_12ck1710 FIND v(dout0_12) AT=1720.05n

.meas tran vdout0_13ck1710 FIND v(dout0_13) AT=1720.05n

.meas tran vdout0_14ck1710 FIND v(dout0_14) AT=1720.05n

.meas tran vdout0_15ck1710 FIND v(dout0_15) AT=1720.05n

.meas tran vdout0_0ck1770 FIND v(dout0_0) AT=1780.05n

.meas tran vdout0_1ck1770 FIND v(dout0_1) AT=1780.05n

.meas tran vdout0_2ck1770 FIND v(dout0_2) AT=1780.05n

.meas tran vdout0_3ck1770 FIND v(dout0_3) AT=1780.05n

.meas tran vdout0_4ck1770 FIND v(dout0_4) AT=1780.05n

.meas tran vdout0_5ck1770 FIND v(dout0_5) AT=1780.05n

.meas tran vdout0_6ck1770 FIND v(dout0_6) AT=1780.05n

.meas tran vdout0_7ck1770 FIND v(dout0_7) AT=1780.05n

.meas tran vdout0_8ck1770 FIND v(dout0_8) AT=1780.05n

.meas tran vdout0_9ck1770 FIND v(dout0_9) AT=1780.05n

.meas tran vdout0_10ck1770 FIND v(dout0_10) AT=1780.05n

.meas tran vdout0_11ck1770 FIND v(dout0_11) AT=1780.05n

.meas tran vdout0_12ck1770 FIND v(dout0_12) AT=1780.05n

.meas tran vdout0_13ck1770 FIND v(dout0_13) AT=1780.05n

.meas tran vdout0_14ck1770 FIND v(dout0_14) AT=1780.05n

.meas tran vdout0_15ck1770 FIND v(dout0_15) AT=1780.05n

.meas tran vdout0_0ck1780 FIND v(dout0_0) AT=1790.05n

.meas tran vdout0_1ck1780 FIND v(dout0_1) AT=1790.05n

.meas tran vdout0_2ck1780 FIND v(dout0_2) AT=1790.05n

.meas tran vdout0_3ck1780 FIND v(dout0_3) AT=1790.05n

.meas tran vdout0_4ck1780 FIND v(dout0_4) AT=1790.05n

.meas tran vdout0_5ck1780 FIND v(dout0_5) AT=1790.05n

.meas tran vdout0_6ck1780 FIND v(dout0_6) AT=1790.05n

.meas tran vdout0_7ck1780 FIND v(dout0_7) AT=1790.05n

.meas tran vdout0_8ck1780 FIND v(dout0_8) AT=1790.05n

.meas tran vdout0_9ck1780 FIND v(dout0_9) AT=1790.05n

.meas tran vdout0_10ck1780 FIND v(dout0_10) AT=1790.05n

.meas tran vdout0_11ck1780 FIND v(dout0_11) AT=1790.05n

.meas tran vdout0_12ck1780 FIND v(dout0_12) AT=1790.05n

.meas tran vdout0_13ck1780 FIND v(dout0_13) AT=1790.05n

.meas tran vdout0_14ck1780 FIND v(dout0_14) AT=1790.05n

.meas tran vdout0_15ck1780 FIND v(dout0_15) AT=1790.05n

.meas tran vdout0_0ck1800 FIND v(dout0_0) AT=1810.05n

.meas tran vdout0_1ck1800 FIND v(dout0_1) AT=1810.05n

.meas tran vdout0_2ck1800 FIND v(dout0_2) AT=1810.05n

.meas tran vdout0_3ck1800 FIND v(dout0_3) AT=1810.05n

.meas tran vdout0_4ck1800 FIND v(dout0_4) AT=1810.05n

.meas tran vdout0_5ck1800 FIND v(dout0_5) AT=1810.05n

.meas tran vdout0_6ck1800 FIND v(dout0_6) AT=1810.05n

.meas tran vdout0_7ck1800 FIND v(dout0_7) AT=1810.05n

.meas tran vdout0_8ck1800 FIND v(dout0_8) AT=1810.05n

.meas tran vdout0_9ck1800 FIND v(dout0_9) AT=1810.05n

.meas tran vdout0_10ck1800 FIND v(dout0_10) AT=1810.05n

.meas tran vdout0_11ck1800 FIND v(dout0_11) AT=1810.05n

.meas tran vdout0_12ck1800 FIND v(dout0_12) AT=1810.05n

.meas tran vdout0_13ck1800 FIND v(dout0_13) AT=1810.05n

.meas tran vdout0_14ck1800 FIND v(dout0_14) AT=1810.05n

.meas tran vdout0_15ck1800 FIND v(dout0_15) AT=1810.05n

.meas tran vdout0_0ck1820 FIND v(dout0_0) AT=1830.05n

.meas tran vdout0_1ck1820 FIND v(dout0_1) AT=1830.05n

.meas tran vdout0_2ck1820 FIND v(dout0_2) AT=1830.05n

.meas tran vdout0_3ck1820 FIND v(dout0_3) AT=1830.05n

.meas tran vdout0_4ck1820 FIND v(dout0_4) AT=1830.05n

.meas tran vdout0_5ck1820 FIND v(dout0_5) AT=1830.05n

.meas tran vdout0_6ck1820 FIND v(dout0_6) AT=1830.05n

.meas tran vdout0_7ck1820 FIND v(dout0_7) AT=1830.05n

.meas tran vdout0_8ck1820 FIND v(dout0_8) AT=1830.05n

.meas tran vdout0_9ck1820 FIND v(dout0_9) AT=1830.05n

.meas tran vdout0_10ck1820 FIND v(dout0_10) AT=1830.05n

.meas tran vdout0_11ck1820 FIND v(dout0_11) AT=1830.05n

.meas tran vdout0_12ck1820 FIND v(dout0_12) AT=1830.05n

.meas tran vdout0_13ck1820 FIND v(dout0_13) AT=1830.05n

.meas tran vdout0_14ck1820 FIND v(dout0_14) AT=1830.05n

.meas tran vdout0_15ck1820 FIND v(dout0_15) AT=1830.05n

.meas tran vdout0_0ck1830 FIND v(dout0_0) AT=1840.05n

.meas tran vdout0_1ck1830 FIND v(dout0_1) AT=1840.05n

.meas tran vdout0_2ck1830 FIND v(dout0_2) AT=1840.05n

.meas tran vdout0_3ck1830 FIND v(dout0_3) AT=1840.05n

.meas tran vdout0_4ck1830 FIND v(dout0_4) AT=1840.05n

.meas tran vdout0_5ck1830 FIND v(dout0_5) AT=1840.05n

.meas tran vdout0_6ck1830 FIND v(dout0_6) AT=1840.05n

.meas tran vdout0_7ck1830 FIND v(dout0_7) AT=1840.05n

.meas tran vdout0_8ck1830 FIND v(dout0_8) AT=1840.05n

.meas tran vdout0_9ck1830 FIND v(dout0_9) AT=1840.05n

.meas tran vdout0_10ck1830 FIND v(dout0_10) AT=1840.05n

.meas tran vdout0_11ck1830 FIND v(dout0_11) AT=1840.05n

.meas tran vdout0_12ck1830 FIND v(dout0_12) AT=1840.05n

.meas tran vdout0_13ck1830 FIND v(dout0_13) AT=1840.05n

.meas tran vdout0_14ck1830 FIND v(dout0_14) AT=1840.05n

.meas tran vdout0_15ck1830 FIND v(dout0_15) AT=1840.05n

.meas tran vdout0_0ck1860 FIND v(dout0_0) AT=1870.05n

.meas tran vdout0_1ck1860 FIND v(dout0_1) AT=1870.05n

.meas tran vdout0_2ck1860 FIND v(dout0_2) AT=1870.05n

.meas tran vdout0_3ck1860 FIND v(dout0_3) AT=1870.05n

.meas tran vdout0_4ck1860 FIND v(dout0_4) AT=1870.05n

.meas tran vdout0_5ck1860 FIND v(dout0_5) AT=1870.05n

.meas tran vdout0_6ck1860 FIND v(dout0_6) AT=1870.05n

.meas tran vdout0_7ck1860 FIND v(dout0_7) AT=1870.05n

.meas tran vdout0_8ck1860 FIND v(dout0_8) AT=1870.05n

.meas tran vdout0_9ck1860 FIND v(dout0_9) AT=1870.05n

.meas tran vdout0_10ck1860 FIND v(dout0_10) AT=1870.05n

.meas tran vdout0_11ck1860 FIND v(dout0_11) AT=1870.05n

.meas tran vdout0_12ck1860 FIND v(dout0_12) AT=1870.05n

.meas tran vdout0_13ck1860 FIND v(dout0_13) AT=1870.05n

.meas tran vdout0_14ck1860 FIND v(dout0_14) AT=1870.05n

.meas tran vdout0_15ck1860 FIND v(dout0_15) AT=1870.05n

.meas tran vdout0_0ck1880 FIND v(dout0_0) AT=1890.05n

.meas tran vdout0_1ck1880 FIND v(dout0_1) AT=1890.05n

.meas tran vdout0_2ck1880 FIND v(dout0_2) AT=1890.05n

.meas tran vdout0_3ck1880 FIND v(dout0_3) AT=1890.05n

.meas tran vdout0_4ck1880 FIND v(dout0_4) AT=1890.05n

.meas tran vdout0_5ck1880 FIND v(dout0_5) AT=1890.05n

.meas tran vdout0_6ck1880 FIND v(dout0_6) AT=1890.05n

.meas tran vdout0_7ck1880 FIND v(dout0_7) AT=1890.05n

.meas tran vdout0_8ck1880 FIND v(dout0_8) AT=1890.05n

.meas tran vdout0_9ck1880 FIND v(dout0_9) AT=1890.05n

.meas tran vdout0_10ck1880 FIND v(dout0_10) AT=1890.05n

.meas tran vdout0_11ck1880 FIND v(dout0_11) AT=1890.05n

.meas tran vdout0_12ck1880 FIND v(dout0_12) AT=1890.05n

.meas tran vdout0_13ck1880 FIND v(dout0_13) AT=1890.05n

.meas tran vdout0_14ck1880 FIND v(dout0_14) AT=1890.05n

.meas tran vdout0_15ck1880 FIND v(dout0_15) AT=1890.05n

.meas tran vdout0_0ck1910 FIND v(dout0_0) AT=1920.05n

.meas tran vdout0_1ck1910 FIND v(dout0_1) AT=1920.05n

.meas tran vdout0_2ck1910 FIND v(dout0_2) AT=1920.05n

.meas tran vdout0_3ck1910 FIND v(dout0_3) AT=1920.05n

.meas tran vdout0_4ck1910 FIND v(dout0_4) AT=1920.05n

.meas tran vdout0_5ck1910 FIND v(dout0_5) AT=1920.05n

.meas tran vdout0_6ck1910 FIND v(dout0_6) AT=1920.05n

.meas tran vdout0_7ck1910 FIND v(dout0_7) AT=1920.05n

.meas tran vdout0_8ck1910 FIND v(dout0_8) AT=1920.05n

.meas tran vdout0_9ck1910 FIND v(dout0_9) AT=1920.05n

.meas tran vdout0_10ck1910 FIND v(dout0_10) AT=1920.05n

.meas tran vdout0_11ck1910 FIND v(dout0_11) AT=1920.05n

.meas tran vdout0_12ck1910 FIND v(dout0_12) AT=1920.05n

.meas tran vdout0_13ck1910 FIND v(dout0_13) AT=1920.05n

.meas tran vdout0_14ck1910 FIND v(dout0_14) AT=1920.05n

.meas tran vdout0_15ck1910 FIND v(dout0_15) AT=1920.05n

.meas tran vdout0_0ck1920 FIND v(dout0_0) AT=1930.05n

.meas tran vdout0_1ck1920 FIND v(dout0_1) AT=1930.05n

.meas tran vdout0_2ck1920 FIND v(dout0_2) AT=1930.05n

.meas tran vdout0_3ck1920 FIND v(dout0_3) AT=1930.05n

.meas tran vdout0_4ck1920 FIND v(dout0_4) AT=1930.05n

.meas tran vdout0_5ck1920 FIND v(dout0_5) AT=1930.05n

.meas tran vdout0_6ck1920 FIND v(dout0_6) AT=1930.05n

.meas tran vdout0_7ck1920 FIND v(dout0_7) AT=1930.05n

.meas tran vdout0_8ck1920 FIND v(dout0_8) AT=1930.05n

.meas tran vdout0_9ck1920 FIND v(dout0_9) AT=1930.05n

.meas tran vdout0_10ck1920 FIND v(dout0_10) AT=1930.05n

.meas tran vdout0_11ck1920 FIND v(dout0_11) AT=1930.05n

.meas tran vdout0_12ck1920 FIND v(dout0_12) AT=1930.05n

.meas tran vdout0_13ck1920 FIND v(dout0_13) AT=1930.05n

.meas tran vdout0_14ck1920 FIND v(dout0_14) AT=1930.05n

.meas tran vdout0_15ck1920 FIND v(dout0_15) AT=1930.05n

.meas tran vdout0_0ck1930 FIND v(dout0_0) AT=1940.05n

.meas tran vdout0_1ck1930 FIND v(dout0_1) AT=1940.05n

.meas tran vdout0_2ck1930 FIND v(dout0_2) AT=1940.05n

.meas tran vdout0_3ck1930 FIND v(dout0_3) AT=1940.05n

.meas tran vdout0_4ck1930 FIND v(dout0_4) AT=1940.05n

.meas tran vdout0_5ck1930 FIND v(dout0_5) AT=1940.05n

.meas tran vdout0_6ck1930 FIND v(dout0_6) AT=1940.05n

.meas tran vdout0_7ck1930 FIND v(dout0_7) AT=1940.05n

.meas tran vdout0_8ck1930 FIND v(dout0_8) AT=1940.05n

.meas tran vdout0_9ck1930 FIND v(dout0_9) AT=1940.05n

.meas tran vdout0_10ck1930 FIND v(dout0_10) AT=1940.05n

.meas tran vdout0_11ck1930 FIND v(dout0_11) AT=1940.05n

.meas tran vdout0_12ck1930 FIND v(dout0_12) AT=1940.05n

.meas tran vdout0_13ck1930 FIND v(dout0_13) AT=1940.05n

.meas tran vdout0_14ck1930 FIND v(dout0_14) AT=1940.05n

.meas tran vdout0_15ck1930 FIND v(dout0_15) AT=1940.05n

.meas tran vdout0_0ck1940 FIND v(dout0_0) AT=1950.05n

.meas tran vdout0_1ck1940 FIND v(dout0_1) AT=1950.05n

.meas tran vdout0_2ck1940 FIND v(dout0_2) AT=1950.05n

.meas tran vdout0_3ck1940 FIND v(dout0_3) AT=1950.05n

.meas tran vdout0_4ck1940 FIND v(dout0_4) AT=1950.05n

.meas tran vdout0_5ck1940 FIND v(dout0_5) AT=1950.05n

.meas tran vdout0_6ck1940 FIND v(dout0_6) AT=1950.05n

.meas tran vdout0_7ck1940 FIND v(dout0_7) AT=1950.05n

.meas tran vdout0_8ck1940 FIND v(dout0_8) AT=1950.05n

.meas tran vdout0_9ck1940 FIND v(dout0_9) AT=1950.05n

.meas tran vdout0_10ck1940 FIND v(dout0_10) AT=1950.05n

.meas tran vdout0_11ck1940 FIND v(dout0_11) AT=1950.05n

.meas tran vdout0_12ck1940 FIND v(dout0_12) AT=1950.05n

.meas tran vdout0_13ck1940 FIND v(dout0_13) AT=1950.05n

.meas tran vdout0_14ck1940 FIND v(dout0_14) AT=1950.05n

.meas tran vdout0_15ck1940 FIND v(dout0_15) AT=1950.05n

.meas tran vdout0_0ck1950 FIND v(dout0_0) AT=1960.05n

.meas tran vdout0_1ck1950 FIND v(dout0_1) AT=1960.05n

.meas tran vdout0_2ck1950 FIND v(dout0_2) AT=1960.05n

.meas tran vdout0_3ck1950 FIND v(dout0_3) AT=1960.05n

.meas tran vdout0_4ck1950 FIND v(dout0_4) AT=1960.05n

.meas tran vdout0_5ck1950 FIND v(dout0_5) AT=1960.05n

.meas tran vdout0_6ck1950 FIND v(dout0_6) AT=1960.05n

.meas tran vdout0_7ck1950 FIND v(dout0_7) AT=1960.05n

.meas tran vdout0_8ck1950 FIND v(dout0_8) AT=1960.05n

.meas tran vdout0_9ck1950 FIND v(dout0_9) AT=1960.05n

.meas tran vdout0_10ck1950 FIND v(dout0_10) AT=1960.05n

.meas tran vdout0_11ck1950 FIND v(dout0_11) AT=1960.05n

.meas tran vdout0_12ck1950 FIND v(dout0_12) AT=1960.05n

.meas tran vdout0_13ck1950 FIND v(dout0_13) AT=1960.05n

.meas tran vdout0_14ck1950 FIND v(dout0_14) AT=1960.05n

.meas tran vdout0_15ck1950 FIND v(dout0_15) AT=1960.05n

.meas tran vdout0_0ck1990 FIND v(dout0_0) AT=2000.05n

.meas tran vdout0_1ck1990 FIND v(dout0_1) AT=2000.05n

.meas tran vdout0_2ck1990 FIND v(dout0_2) AT=2000.05n

.meas tran vdout0_3ck1990 FIND v(dout0_3) AT=2000.05n

.meas tran vdout0_4ck1990 FIND v(dout0_4) AT=2000.05n

.meas tran vdout0_5ck1990 FIND v(dout0_5) AT=2000.05n

.meas tran vdout0_6ck1990 FIND v(dout0_6) AT=2000.05n

.meas tran vdout0_7ck1990 FIND v(dout0_7) AT=2000.05n

.meas tran vdout0_8ck1990 FIND v(dout0_8) AT=2000.05n

.meas tran vdout0_9ck1990 FIND v(dout0_9) AT=2000.05n

.meas tran vdout0_10ck1990 FIND v(dout0_10) AT=2000.05n

.meas tran vdout0_11ck1990 FIND v(dout0_11) AT=2000.05n

.meas tran vdout0_12ck1990 FIND v(dout0_12) AT=2000.05n

.meas tran vdout0_13ck1990 FIND v(dout0_13) AT=2000.05n

.meas tran vdout0_14ck1990 FIND v(dout0_14) AT=2000.05n

.meas tran vdout0_15ck1990 FIND v(dout0_15) AT=2000.05n

.meas tran vdout0_0ck2010 FIND v(dout0_0) AT=2020.05n

.meas tran vdout0_1ck2010 FIND v(dout0_1) AT=2020.05n

.meas tran vdout0_2ck2010 FIND v(dout0_2) AT=2020.05n

.meas tran vdout0_3ck2010 FIND v(dout0_3) AT=2020.05n

.meas tran vdout0_4ck2010 FIND v(dout0_4) AT=2020.05n

.meas tran vdout0_5ck2010 FIND v(dout0_5) AT=2020.05n

.meas tran vdout0_6ck2010 FIND v(dout0_6) AT=2020.05n

.meas tran vdout0_7ck2010 FIND v(dout0_7) AT=2020.05n

.meas tran vdout0_8ck2010 FIND v(dout0_8) AT=2020.05n

.meas tran vdout0_9ck2010 FIND v(dout0_9) AT=2020.05n

.meas tran vdout0_10ck2010 FIND v(dout0_10) AT=2020.05n

.meas tran vdout0_11ck2010 FIND v(dout0_11) AT=2020.05n

.meas tran vdout0_12ck2010 FIND v(dout0_12) AT=2020.05n

.meas tran vdout0_13ck2010 FIND v(dout0_13) AT=2020.05n

.meas tran vdout0_14ck2010 FIND v(dout0_14) AT=2020.05n

.meas tran vdout0_15ck2010 FIND v(dout0_15) AT=2020.05n

.meas tran vdout0_0ck2020 FIND v(dout0_0) AT=2030.05n

.meas tran vdout0_1ck2020 FIND v(dout0_1) AT=2030.05n

.meas tran vdout0_2ck2020 FIND v(dout0_2) AT=2030.05n

.meas tran vdout0_3ck2020 FIND v(dout0_3) AT=2030.05n

.meas tran vdout0_4ck2020 FIND v(dout0_4) AT=2030.05n

.meas tran vdout0_5ck2020 FIND v(dout0_5) AT=2030.05n

.meas tran vdout0_6ck2020 FIND v(dout0_6) AT=2030.05n

.meas tran vdout0_7ck2020 FIND v(dout0_7) AT=2030.05n

.meas tran vdout0_8ck2020 FIND v(dout0_8) AT=2030.05n

.meas tran vdout0_9ck2020 FIND v(dout0_9) AT=2030.05n

.meas tran vdout0_10ck2020 FIND v(dout0_10) AT=2030.05n

.meas tran vdout0_11ck2020 FIND v(dout0_11) AT=2030.05n

.meas tran vdout0_12ck2020 FIND v(dout0_12) AT=2030.05n

.meas tran vdout0_13ck2020 FIND v(dout0_13) AT=2030.05n

.meas tran vdout0_14ck2020 FIND v(dout0_14) AT=2030.05n

.meas tran vdout0_15ck2020 FIND v(dout0_15) AT=2030.05n

.meas tran vdout0_0ck2040 FIND v(dout0_0) AT=2050.05n

.meas tran vdout0_1ck2040 FIND v(dout0_1) AT=2050.05n

.meas tran vdout0_2ck2040 FIND v(dout0_2) AT=2050.05n

.meas tran vdout0_3ck2040 FIND v(dout0_3) AT=2050.05n

.meas tran vdout0_4ck2040 FIND v(dout0_4) AT=2050.05n

.meas tran vdout0_5ck2040 FIND v(dout0_5) AT=2050.05n

.meas tran vdout0_6ck2040 FIND v(dout0_6) AT=2050.05n

.meas tran vdout0_7ck2040 FIND v(dout0_7) AT=2050.05n

.meas tran vdout0_8ck2040 FIND v(dout0_8) AT=2050.05n

.meas tran vdout0_9ck2040 FIND v(dout0_9) AT=2050.05n

.meas tran vdout0_10ck2040 FIND v(dout0_10) AT=2050.05n

.meas tran vdout0_11ck2040 FIND v(dout0_11) AT=2050.05n

.meas tran vdout0_12ck2040 FIND v(dout0_12) AT=2050.05n

.meas tran vdout0_13ck2040 FIND v(dout0_13) AT=2050.05n

.meas tran vdout0_14ck2040 FIND v(dout0_14) AT=2050.05n

.meas tran vdout0_15ck2040 FIND v(dout0_15) AT=2050.05n
