* Functional test stimulus file for 10ns period

* TT process corner
.include "/usr/local/lib/python3.13/site-packages/openram/technology/scn4m_subm/models/nom/pmos.sp"
.include "/usr/local/lib/python3.13/site-packages/openram/technology/scn4m_subm/models/nom/nmos.sp"
.include "/tmp/openram_root_295_temp/sram.sp"

* Global Power Supplies
Vvdd vdd 0 5.0

*Nodes gnd and 0 are the same global ground node in ngspice/hspice/xa. Otherwise, this source may be needed.
*Vgnd gnd 0 0.0

* Instantiation of the SRAM
Xsram_16x16_scn4m din0_0 din0_1 din0_2 din0_3 din0_4 din0_5 din0_6 din0_7 din0_8 din0_9 din0_10 din0_11 din0_12 din0_13 din0_14 din0_15 a0_0 a0_1 a0_2 a0_3 CSB0 WEB0 clk0 dout0_0 dout0_1 dout0_2 dout0_3 dout0_4 dout0_5 dout0_6 dout0_7 dout0_8 dout0_9 dout0_10 dout0_11 dout0_12 dout0_13 dout0_14 dout0_15 vdd gnd sram_16x16_scn4m

* SRAM output loads
CD00 dout0_0  0 39.2968f
CD01 dout0_1  0 39.2968f
CD02 dout0_2  0 39.2968f
CD03 dout0_3  0 39.2968f
CD04 dout0_4  0 39.2968f
CD05 dout0_5  0 39.2968f
CD06 dout0_6  0 39.2968f
CD07 dout0_7  0 39.2968f
CD08 dout0_8  0 39.2968f
CD09 dout0_9  0 39.2968f
CD010 dout0_10  0 39.2968f
CD011 dout0_11  0 39.2968f
CD012 dout0_12  0 39.2968f
CD013 dout0_13  0 39.2968f
CD014 dout0_14  0 39.2968f
CD015 dout0_15  0 39.2968f

* Important signals for debug
* bl:	xsram:xbank0:bl_0_0
* br:	xsram:xbank0:br_0_0
* s_en:	xsram:s_en
* q:	xsram:xbank0:xbitcell_array:xbitcell_array:xbit_r0_c0.Q
* qbar:	xsram:xbank0:xbitcell_array:xbitcell_array:xbit_r0_c0.Q_bar

* Sequence of operations
*	Idle during cycle 0 (0ns - 10ns)
*	Writing 1100110000111001  to  address 0000 (from port 0) during cycle 1 (10ns - 20ns)
*	Writing 1100011100111110  to  address 0000 (from port 0) during cycle 2 (20ns - 30ns)
*	Writing 0101000111001000  to  address 0000 (from port 0) during cycle 3 (30ns - 40ns)
*	Reading 0101000111001000 from address 0000 (from port 0) during cycle 4 (40ns - 50ns)
*	Reading 0101000111001000 from address 0000 (from port 0) during cycle 5 (50ns - 60ns)
*	Reading 0101000111001000 from address 0000 (from port 0) during cycle 6 (60ns - 70ns)
*	Reading 0101000111001000 from address 0000 (from port 0) during cycle 7 (70ns - 80ns)
*	Reading 0101000111001000 from address 0000 (from port 0) during cycle 10 (100ns - 110ns)
*	Writing 0001001000011011  to  address 0000 (from port 0) during cycle 12 (120ns - 130ns)
*	Writing 0110000110011111  to  address 0000 (from port 0) during cycle 13 (130ns - 140ns)
*	Writing 1100000000111000  to  address 0000 (from port 0) during cycle 17 (170ns - 180ns)
*	Writing 1100110011000010  to  address 0000 (from port 0) during cycle 18 (180ns - 190ns)
*	Reading 1100110011000010 from address 0000 (from port 0) during cycle 19 (190ns - 200ns)
*	Reading 1100110011000010 from address 0000 (from port 0) during cycle 20 (200ns - 210ns)
*	Reading 1100110011000010 from address 0000 (from port 0) during cycle 21 (210ns - 220ns)
*	Reading 1100110011000010 from address 0000 (from port 0) during cycle 23 (230ns - 240ns)
*	Reading 1100110011000010 from address 0000 (from port 0) during cycle 25 (250ns - 260ns)
*	Reading 1100110011000010 from address 0000 (from port 0) during cycle 26 (260ns - 270ns)
*	Reading 1100110011000010 from address 0000 (from port 0) during cycle 27 (270ns - 280ns)
*	Reading 1100110011000010 from address 0000 (from port 0) during cycle 28 (280ns - 290ns)
*	Writing 0101000001101001  to  address 1110 (from port 0) during cycle 29 (290ns - 300ns)
*	Writing 1100010010100000  to  address 1110 (from port 0) during cycle 30 (300ns - 310ns)
*	Reading 1100010010100000 from address 1110 (from port 0) during cycle 31 (310ns - 320ns)
*	Reading 1100110011000010 from address 0000 (from port 0) during cycle 32 (320ns - 330ns)
*	Writing 1010000000110101  to  address 1110 (from port 0) during cycle 35 (350ns - 360ns)
*	Writing 1101001010111111  to  address 0000 (from port 0) during cycle 36 (360ns - 370ns)
*	Reading 1010000000110101 from address 1110 (from port 0) during cycle 37 (370ns - 380ns)
*	Reading 1101001010111111 from address 0000 (from port 0) during cycle 39 (390ns - 400ns)
*	Reading 1101001010111111 from address 0000 (from port 0) during cycle 41 (410ns - 420ns)
*	Writing 0000000001001100  to  address 0000 (from port 0) during cycle 42 (420ns - 430ns)
*	Reading 0000000001001100 from address 0000 (from port 0) during cycle 44 (440ns - 450ns)
*	Writing 1100011000010011  to  address 1110 (from port 0) during cycle 45 (450ns - 460ns)
*	Reading 1100011000010011 from address 1110 (from port 0) during cycle 46 (460ns - 470ns)
*	Reading 1100011000010011 from address 1110 (from port 0) during cycle 47 (470ns - 480ns)
*	Reading 1100011000010011 from address 1110 (from port 0) during cycle 48 (480ns - 490ns)
*	Writing 1011011111110110  to  address 1110 (from port 0) during cycle 50 (500ns - 510ns)
*	Reading 0000000001001100 from address 0000 (from port 0) during cycle 51 (510ns - 520ns)
*	Reading 0000000001001100 from address 0000 (from port 0) during cycle 53 (530ns - 540ns)
*	Reading 0000000001001100 from address 0000 (from port 0) during cycle 54 (540ns - 550ns)
*	Reading 1011011111110110 from address 1110 (from port 0) during cycle 55 (550ns - 560ns)
*	Reading 1011011111110110 from address 1110 (from port 0) during cycle 57 (570ns - 580ns)
*	Reading 0000000001001100 from address 0000 (from port 0) during cycle 58 (580ns - 590ns)
*	Reading 0000000001001100 from address 0000 (from port 0) during cycle 59 (590ns - 600ns)
*	Reading 0000000001001100 from address 0000 (from port 0) during cycle 60 (600ns - 610ns)
*	Reading 1011011111110110 from address 1110 (from port 0) during cycle 61 (610ns - 620ns)
*	Writing 1011100110111010  to  address 0000 (from port 0) during cycle 64 (640ns - 650ns)
*	Writing 1101101101111000  to  address 0000 (from port 0) during cycle 65 (650ns - 660ns)
*	Reading 1011011111110110 from address 1110 (from port 0) during cycle 66 (660ns - 670ns)
*	Reading 1011011111110110 from address 1110 (from port 0) during cycle 67 (670ns - 680ns)
*	Reading 1011011111110110 from address 1110 (from port 0) during cycle 69 (690ns - 700ns)
*	Writing 1100101110111011  to  address 1110 (from port 0) during cycle 70 (700ns - 710ns)
*	Reading 1100101110111011 from address 1110 (from port 0) during cycle 71 (710ns - 720ns)
*	Reading 1101101101111000 from address 0000 (from port 0) during cycle 72 (720ns - 730ns)
*	Reading 1101101101111000 from address 0000 (from port 0) during cycle 73 (730ns - 740ns)
*	Reading 1100101110111011 from address 1110 (from port 0) during cycle 74 (740ns - 750ns)
*	Writing 1110000100001001  to  address 0000 (from port 0) during cycle 75 (750ns - 760ns)
*	Reading 1110000100001001 from address 0000 (from port 0) during cycle 77 (770ns - 780ns)
*	Reading 1110000100001001 from address 0000 (from port 0) during cycle 80 (800ns - 810ns)
*	Reading 1100101110111011 from address 1110 (from port 0) during cycle 81 (810ns - 820ns)
*	Reading 1110000100001001 from address 0000 (from port 0) during cycle 82 (820ns - 830ns)
*	Reading 1100101110111011 from address 1110 (from port 0) during cycle 83 (830ns - 840ns)
*	Writing 0111101100011111  to  address 1110 (from port 0) during cycle 84 (840ns - 850ns)
*	Reading 1110000100001001 from address 0000 (from port 0) during cycle 85 (850ns - 860ns)
*	Reading 1110000100001001 from address 0000 (from port 0) during cycle 86 (860ns - 870ns)
*	Reading 1110000100001001 from address 0000 (from port 0) during cycle 87 (870ns - 880ns)
*	Writing 0100011110110100  to  address 1110 (from port 0) during cycle 88 (880ns - 890ns)
*	Reading 1110000100001001 from address 0000 (from port 0) during cycle 89 (890ns - 900ns)
*	Reading 0100011110110100 from address 1110 (from port 0) during cycle 91 (910ns - 920ns)
*	Reading 0100011110110100 from address 1110 (from port 0) during cycle 92 (920ns - 930ns)
*	Reading 1110000100001001 from address 0000 (from port 0) during cycle 93 (930ns - 940ns)
*	Writing 0001111111011110  to  address 1110 (from port 0) during cycle 94 (940ns - 950ns)
*	Writing 0111000101110001  to  address 1110 (from port 0) during cycle 95 (950ns - 960ns)
*	Reading 0111000101110001 from address 1110 (from port 0) during cycle 96 (960ns - 970ns)
*	Reading 1110000100001001 from address 0000 (from port 0) during cycle 97 (970ns - 980ns)
*	Reading 0111000101110001 from address 1110 (from port 0) during cycle 98 (980ns - 990ns)
*	Writing 0100110011000001  to  address 0000 (from port 0) during cycle 99 (990ns - 1000ns)
*	Reading 0111000101110001 from address 1110 (from port 0) during cycle 100 (1000ns - 1010ns)
*	Reading 0100110011000001 from address 0000 (from port 0) during cycle 101 (1010ns - 1020ns)
*	Reading 0111000101110001 from address 1110 (from port 0) during cycle 102 (1020ns - 1030ns)
*	Writing 0101000011011110  to  address 0000 (from port 0) during cycle 103 (1030ns - 1040ns)
*	Writing 0011111001001101  to  address 0000 (from port 0) during cycle 104 (1040ns - 1050ns)
*	Reading 0111000101110001 from address 1110 (from port 0) during cycle 106 (1060ns - 1070ns)
*	Writing 0110010010101010  to  address 0000 (from port 0) during cycle 107 (1070ns - 1080ns)
*	Reading 0110010010101010 from address 0000 (from port 0) during cycle 108 (1080ns - 1090ns)
*	Reading 0111000101110001 from address 1110 (from port 0) during cycle 110 (1100ns - 1110ns)
*	Reading 0111000101110001 from address 1110 (from port 0) during cycle 111 (1110ns - 1120ns)
*	Reading 0110010010101010 from address 0000 (from port 0) during cycle 114 (1140ns - 1150ns)
*	Writing 0110110011010010  to  address 1110 (from port 0) during cycle 115 (1150ns - 1160ns)
*	Writing 1101110010000100  to  address 0000 (from port 0) during cycle 116 (1160ns - 1170ns)
*	Reading 0110110011010010 from address 1110 (from port 0) during cycle 117 (1170ns - 1180ns)
*	Writing 0100100100011001  to  address 0000 (from port 0) during cycle 118 (1180ns - 1190ns)
*	Reading 0100100100011001 from address 0000 (from port 0) during cycle 119 (1190ns - 1200ns)
*	Writing 0101100010110001  to  address 1110 (from port 0) during cycle 121 (1210ns - 1220ns)
*	Writing 1100000000000010  to  address 0000 (from port 0) during cycle 122 (1220ns - 1230ns)
*	Reading 1100000000000010 from address 0000 (from port 0) during cycle 123 (1230ns - 1240ns)
*	Writing 1100011010001010  to  address 1110 (from port 0) during cycle 124 (1240ns - 1250ns)
*	Reading 1100011010001010 from address 1110 (from port 0) during cycle 125 (1250ns - 1260ns)
*	Reading 1100011010001010 from address 1110 (from port 0) during cycle 126 (1260ns - 1270ns)
*	Writing 1111111100010001  to  address 0000 (from port 0) during cycle 128 (1280ns - 1290ns)
*	Writing 0100010101001111  to  address 0000 (from port 0) during cycle 129 (1290ns - 1300ns)
*	Reading 0100010101001111 from address 0000 (from port 0) during cycle 130 (1300ns - 1310ns)
*	Reading 1100011010001010 from address 1110 (from port 0) during cycle 131 (1310ns - 1320ns)
*	Writing 1110011010000010  to  address 0000 (from port 0) during cycle 132 (1320ns - 1330ns)
*	Reading 1100011010001010 from address 1110 (from port 0) during cycle 133 (1330ns - 1340ns)
*	Reading 1110011010000010 from address 0000 (from port 0) during cycle 135 (1350ns - 1360ns)
*	Writing 0110100111111011  to  address 1110 (from port 0) during cycle 136 (1360ns - 1370ns)
*	Reading 0110100111111011 from address 1110 (from port 0) during cycle 138 (1380ns - 1390ns)
*	Writing 1011100111010001  to  address 1110 (from port 0) during cycle 140 (1400ns - 1410ns)
*	Reading 1011100111010001 from address 1110 (from port 0) during cycle 141 (1410ns - 1420ns)
*	Reading 1110011010000010 from address 0000 (from port 0) during cycle 143 (1430ns - 1440ns)
*	Reading 1011100111010001 from address 1110 (from port 0) during cycle 144 (1440ns - 1450ns)
*	Reading 1011100111010001 from address 1110 (from port 0) during cycle 145 (1450ns - 1460ns)
*	Reading 1110011010000010 from address 0000 (from port 0) during cycle 147 (1470ns - 1480ns)
*	Reading 1011100111010001 from address 1110 (from port 0) during cycle 148 (1480ns - 1490ns)
*	Reading 1011100111010001 from address 1110 (from port 0) during cycle 150 (1500ns - 1510ns)
*	Reading 1110011010000010 from address 0000 (from port 0) during cycle 151 (1510ns - 1520ns)
*	Reading 1011100111010001 from address 1110 (from port 0) during cycle 152 (1520ns - 1530ns)
*	Writing 1001000111100100  to  address 0000 (from port 0) during cycle 153 (1530ns - 1540ns)
*	Reading 1011100111010001 from address 1110 (from port 0) during cycle 155 (1550ns - 1560ns)
*	Reading 1011100111010001 from address 1110 (from port 0) during cycle 156 (1560ns - 1570ns)
*	Reading 1011100111010001 from address 1110 (from port 0) during cycle 158 (1580ns - 1590ns)
*	Reading 1001000111100100 from address 0000 (from port 0) during cycle 159 (1590ns - 1600ns)
*	Reading 1011100111010001 from address 1110 (from port 0) during cycle 160 (1600ns - 1610ns)
*	Reading 1001000111100100 from address 0000 (from port 0) during cycle 163 (1630ns - 1640ns)
*	Reading 1001000111100100 from address 0000 (from port 0) during cycle 164 (1640ns - 1650ns)
*	Writing 0000010001111100  to  address 1110 (from port 0) during cycle 167 (1670ns - 1680ns)
*	Reading 0000010001111100 from address 1110 (from port 0) during cycle 168 (1680ns - 1690ns)
*	Reading 1001000111100100 from address 0000 (from port 0) during cycle 170 (1700ns - 1710ns)
*	Reading 0000010001111100 from address 1110 (from port 0) during cycle 171 (1710ns - 1720ns)
*	Writing 0110111100110011  to  address 1110 (from port 0) during cycle 172 (1720ns - 1730ns)
*	Writing 1010011000111000  to  address 0000 (from port 0) during cycle 173 (1730ns - 1740ns)
*	Writing 0000110001000010  to  address 1110 (from port 0) during cycle 174 (1740ns - 1750ns)
*	Writing 1000010011011010  to  address 1110 (from port 0) during cycle 175 (1750ns - 1760ns)
*	Reading 1010011000111000 from address 0000 (from port 0) during cycle 177 (1770ns - 1780ns)
*	Reading 1010011000111000 from address 0000 (from port 0) during cycle 178 (1780ns - 1790ns)
*	Writing 0001110000110010  to  address 0000 (from port 0) during cycle 179 (1790ns - 1800ns)
*	Reading 1000010011011010 from address 1110 (from port 0) during cycle 180 (1800ns - 1810ns)
*	Writing 1001111000011111  to  address 0000 (from port 0) during cycle 181 (1810ns - 1820ns)
*	Reading 1001111000011111 from address 0000 (from port 0) during cycle 182 (1820ns - 1830ns)
*	Reading 1001111000011111 from address 0000 (from port 0) during cycle 183 (1830ns - 1840ns)
*	Writing 1001111111001101  to  address 1110 (from port 0) during cycle 185 (1850ns - 1860ns)
*	Reading 1001111111001101 from address 1110 (from port 0) during cycle 186 (1860ns - 1870ns)
*	Reading 1001111000011111 from address 0000 (from port 0) during cycle 188 (1880ns - 1890ns)
*	Reading 1001111000011111 from address 0000 (from port 0) during cycle 191 (1910ns - 1920ns)
*	Reading 1001111000011111 from address 0000 (from port 0) during cycle 192 (1920ns - 1930ns)
*	Reading 1001111111001101 from address 1110 (from port 0) during cycle 193 (1930ns - 1940ns)
*	Reading 1001111111001101 from address 1110 (from port 0) during cycle 194 (1940ns - 1950ns)
*	Reading 1001111000011111 from address 0000 (from port 0) during cycle 195 (1950ns - 1960ns)
*	Writing 0111000001010001  to  address 1110 (from port 0) during cycle 197 (1970ns - 1980ns)
*	Reading 1001111000011111 from address 0000 (from port 0) during cycle 199 (1990ns - 2000ns)
*	Reading 1001111000011111 from address 0000 (from port 0) during cycle 201 (2010ns - 2020ns)
*	Reading 0111000001010001 from address 1110 (from port 0) during cycle 202 (2020ns - 2030ns)
*	Reading 0111000001010001 from address 1110 (from port 0) during cycle 204 (2040ns - 2050ns)
*	Idle during cycle 205 (2050ns - 2060ns)

* Generation of data and address signals
* (time, data): [(0, 0), (10, 1), (20, 0), (30, 0), (40, 0), (50, 0), (60, 0), (70, 0), (80, 0), (90, 0), (100, 0), (110, 0), (120, 1), (130, 1), (140, 1), (150, 1), (160, 1), (170, 0), (180, 0), (190, 0), (200, 0), (210, 0), (220, 0), (230, 0), (240, 0), (250, 0), (260, 0), (270, 0), (280, 0), (290, 1), (300, 0), (310, 0), (320, 0), (330, 0), (340, 0), (350, 1), (360, 1), (370, 1), (380, 1), (390, 1), (400, 1), (410, 1), (420, 0), (430, 0), (440, 0), (450, 1), (460, 1), (470, 1), (480, 1), (490, 1), (500, 0), (510, 0), (520, 0), (530, 0), (540, 0), (550, 0), (560, 0), (570, 0), (580, 0), (590, 0), (600, 0), (610, 0), (620, 0), (630, 0), (640, 0), (650, 0), (660, 0), (670, 0), (680, 0), (690, 0), (700, 1), (710, 1), (720, 1), (730, 1), (740, 1), (750, 1), (760, 1), (770, 1), (780, 1), (790, 1), (800, 1), (810, 1), (820, 1), (830, 1), (840, 1), (850, 1), (860, 1), (870, 1), (880, 0), (890, 0), (900, 0), (910, 0), (920, 0), (930, 0), (940, 0), (950, 1), (960, 1), (970, 1), (980, 1), (990, 1), (1000, 1), (1010, 1), (1020, 1), (1030, 0), (1040, 1), (1050, 1), (1060, 1), (1070, 0), (1080, 0), (1090, 0), (1100, 0), (1110, 0), (1120, 0), (1130, 0), (1140, 0), (1150, 0), (1160, 0), (1170, 0), (1180, 1), (1190, 1), (1200, 1), (1210, 1), (1220, 0), (1230, 0), (1240, 0), (1250, 0), (1260, 0), (1270, 0), (1280, 1), (1290, 1), (1300, 1), (1310, 1), (1320, 0), (1330, 0), (1340, 0), (1350, 0), (1360, 1), (1370, 1), (1380, 1), (1390, 1), (1400, 1), (1410, 1), (1420, 1), (1430, 1), (1440, 1), (1450, 1), (1460, 1), (1470, 1), (1480, 1), (1490, 1), (1500, 1), (1510, 1), (1520, 1), (1530, 0), (1540, 0), (1550, 0), (1560, 0), (1570, 0), (1580, 0), (1590, 0), (1600, 0), (1610, 0), (1620, 0), (1630, 0), (1640, 0), (1650, 0), (1660, 0), (1670, 0), (1680, 0), (1690, 0), (1700, 0), (1710, 0), (1720, 1), (1730, 0), (1740, 0), (1750, 0), (1760, 0), (1770, 0), (1780, 0), (1790, 0), (1800, 0), (1810, 1), (1820, 1), (1830, 1), (1840, 1), (1850, 1), (1860, 1), (1870, 1), (1880, 1), (1890, 1), (1900, 1), (1910, 1), (1920, 1), (1930, 1), (1940, 1), (1950, 1), (1960, 1), (1970, 1), (1980, 1), (1990, 1), (2000, 1), (2010, 1), (2020, 1), (2030, 1), (2040, 1), (2050, 1)]
Vdin0_0  din0_0  0 PWL (0n 0.0v 9.45n 0.0v 9.55n 5.0v 19.45n 5.0v 19.55n 0.0v 29.45n 0.0v 29.55n 0.0v 39.45n 0.0v 39.55n 0.0v 49.45n 0.0v 49.55n 0.0v 59.45n 0.0v 59.55n 0.0v 69.45n 0.0v 69.55n 0.0v 79.45n 0.0v 79.55n 0.0v 89.45n 0.0v 89.55n 0.0v 99.45n 0.0v 99.55n 0.0v 109.45n 0.0v 109.55n 0.0v 119.45n 0.0v 119.55n 5.0v 129.45n 5.0v 129.55n 5.0v 139.45n 5.0v 139.55n 5.0v 149.45n 5.0v 149.55n 5.0v 159.45n 5.0v 159.55n 5.0v 169.45n 5.0v 169.55n 0.0v 179.45n 0.0v 179.55n 0.0v 189.45n 0.0v 189.55n 0.0v 199.45n 0.0v 199.55n 0.0v 209.45n 0.0v 209.55n 0.0v 219.45n 0.0v 219.55n 0.0v 229.45n 0.0v 229.55n 0.0v 239.45n 0.0v 239.55n 0.0v 249.45n 0.0v 249.55n 0.0v 259.45n 0.0v 259.55n 0.0v 269.45n 0.0v 269.55n 0.0v 279.45n 0.0v 279.55n 0.0v 289.45n 0.0v 289.55n 5.0v 299.45n 5.0v 299.55n 0.0v 309.45n 0.0v 309.55n 0.0v 319.45n 0.0v 319.55n 0.0v 329.45n 0.0v 329.55n 0.0v 339.45n 0.0v 339.55n 0.0v 349.45n 0.0v 349.55n 5.0v 359.45n 5.0v 359.55n 5.0v 369.45n 5.0v 369.55n 5.0v 379.45n 5.0v 379.55n 5.0v 389.45n 5.0v 389.55n 5.0v 399.45n 5.0v 399.55n 5.0v 409.45n 5.0v 409.55n 5.0v 419.45n 5.0v 419.55n 0.0v 429.45n 0.0v 429.55n 0.0v 439.45n 0.0v 439.55n 0.0v 449.45n 0.0v 449.55n 5.0v 459.45n 5.0v 459.55n 5.0v 469.45n 5.0v 469.55n 5.0v 479.45n 5.0v 479.55n 5.0v 489.45n 5.0v 489.55n 5.0v 499.45n 5.0v 499.55n 0.0v 509.45n 0.0v 509.55n 0.0v 519.45n 0.0v 519.55n 0.0v 529.45n 0.0v 529.55n 0.0v 539.45n 0.0v 539.55n 0.0v 549.45n 0.0v 549.55n 0.0v 559.45n 0.0v 559.55n 0.0v 569.45n 0.0v 569.55n 0.0v 579.45n 0.0v 579.55n 0.0v 589.45n 0.0v 589.55n 0.0v 599.45n 0.0v 599.55n 0.0v 609.45n 0.0v 609.55n 0.0v 619.45n 0.0v 619.55n 0.0v 629.45n 0.0v 629.55n 0.0v 639.45n 0.0v 639.55n 0.0v 649.45n 0.0v 649.55n 0.0v 659.45n 0.0v 659.55n 0.0v 669.45n 0.0v 669.55n 0.0v 679.45n 0.0v 679.55n 0.0v 689.45n 0.0v 689.55n 0.0v 699.45n 0.0v 699.55n 5.0v 709.45n 5.0v 709.55n 5.0v 719.45n 5.0v 719.55n 5.0v 729.45n 5.0v 729.55n 5.0v 739.45n 5.0v 739.55n 5.0v 749.45n 5.0v 749.55n 5.0v 759.45n 5.0v 759.55n 5.0v 769.45n 5.0v 769.55n 5.0v 779.45n 5.0v 779.55n 5.0v 789.45n 5.0v 789.55n 5.0v 799.45n 5.0v 799.55n 5.0v 809.45n 5.0v 809.55n 5.0v 819.45n 5.0v 819.55n 5.0v 829.45n 5.0v 829.55n 5.0v 839.45n 5.0v 839.55n 5.0v 849.45n 5.0v 849.55n 5.0v 859.45n 5.0v 859.55n 5.0v 869.45n 5.0v 869.55n 5.0v 879.45n 5.0v 879.55n 0.0v 889.45n 0.0v 889.55n 0.0v 899.45n 0.0v 899.55n 0.0v 909.45n 0.0v 909.55n 0.0v 919.45n 0.0v 919.55n 0.0v 929.45n 0.0v 929.55n 0.0v 939.45n 0.0v 939.55n 0.0v 949.45n 0.0v 949.55n 5.0v 959.45n 5.0v 959.55n 5.0v 969.45n 5.0v 969.55n 5.0v 979.45n 5.0v 979.55n 5.0v 989.45n 5.0v 989.55n 5.0v 999.45n 5.0v 999.55n 5.0v 1009.45n 5.0v 1009.55n 5.0v 1019.45n 5.0v 1019.55n 5.0v 1029.45n 5.0v 1029.55n 0.0v 1039.45n 0.0v 1039.55n 5.0v 1049.45n 5.0v 1049.55n 5.0v 1059.45n 5.0v 1059.55n 5.0v 1069.45n 5.0v 1069.55n 0.0v 1079.45n 0.0v 1079.55n 0.0v 1089.45n 0.0v 1089.55n 0.0v 1099.45n 0.0v 1099.55n 0.0v 1109.45n 0.0v 1109.55n 0.0v 1119.45n 0.0v 1119.55n 0.0v 1129.45n 0.0v 1129.55n 0.0v 1139.45n 0.0v 1139.55n 0.0v 1149.45n 0.0v 1149.55n 0.0v 1159.45n 0.0v 1159.55n 0.0v 1169.45n 0.0v 1169.55n 0.0v 1179.45n 0.0v 1179.55n 5.0v 1189.45n 5.0v 1189.55n 5.0v 1199.45n 5.0v 1199.55n 5.0v 1209.45n 5.0v 1209.55n 5.0v 1219.45n 5.0v 1219.55n 0.0v 1229.45n 0.0v 1229.55n 0.0v 1239.45n 0.0v 1239.55n 0.0v 1249.45n 0.0v 1249.55n 0.0v 1259.45n 0.0v 1259.55n 0.0v 1269.45n 0.0v 1269.55n 0.0v 1279.45n 0.0v 1279.55n 5.0v 1289.45n 5.0v 1289.55n 5.0v 1299.45n 5.0v 1299.55n 5.0v 1309.45n 5.0v 1309.55n 5.0v 1319.45n 5.0v 1319.55n 0.0v 1329.45n 0.0v 1329.55n 0.0v 1339.45n 0.0v 1339.55n 0.0v 1349.45n 0.0v 1349.55n 0.0v 1359.45n 0.0v 1359.55n 5.0v 1369.45n 5.0v 1369.55n 5.0v 1379.45n 5.0v 1379.55n 5.0v 1389.45n 5.0v 1389.55n 5.0v 1399.45n 5.0v 1399.55n 5.0v 1409.45n 5.0v 1409.55n 5.0v 1419.45n 5.0v 1419.55n 5.0v 1429.45n 5.0v 1429.55n 5.0v 1439.45n 5.0v 1439.55n 5.0v 1449.45n 5.0v 1449.55n 5.0v 1459.45n 5.0v 1459.55n 5.0v 1469.45n 5.0v 1469.55n 5.0v 1479.45n 5.0v 1479.55n 5.0v 1489.45n 5.0v 1489.55n 5.0v 1499.45n 5.0v 1499.55n 5.0v 1509.45n 5.0v 1509.55n 5.0v 1519.45n 5.0v 1519.55n 5.0v 1529.45n 5.0v 1529.55n 0.0v 1539.45n 0.0v 1539.55n 0.0v 1549.45n 0.0v 1549.55n 0.0v 1559.45n 0.0v 1559.55n 0.0v 1569.45n 0.0v 1569.55n 0.0v 1579.45n 0.0v 1579.55n 0.0v 1589.45n 0.0v 1589.55n 0.0v 1599.45n 0.0v 1599.55n 0.0v 1609.45n 0.0v 1609.55n 0.0v 1619.45n 0.0v 1619.55n 0.0v 1629.45n 0.0v 1629.55n 0.0v 1639.45n 0.0v 1639.55n 0.0v 1649.45n 0.0v 1649.55n 0.0v 1659.45n 0.0v 1659.55n 0.0v 1669.45n 0.0v 1669.55n 0.0v 1679.45n 0.0v 1679.55n 0.0v 1689.45n 0.0v 1689.55n 0.0v 1699.45n 0.0v 1699.55n 0.0v 1709.45n 0.0v 1709.55n 0.0v 1719.45n 0.0v 1719.55n 5.0v 1729.45n 5.0v 1729.55n 0.0v 1739.45n 0.0v 1739.55n 0.0v 1749.45n 0.0v 1749.55n 0.0v 1759.45n 0.0v 1759.55n 0.0v 1769.45n 0.0v 1769.55n 0.0v 1779.45n 0.0v 1779.55n 0.0v 1789.45n 0.0v 1789.55n 0.0v 1799.45n 0.0v 1799.55n 0.0v 1809.45n 0.0v 1809.55n 5.0v 1819.45n 5.0v 1819.55n 5.0v 1829.45n 5.0v 1829.55n 5.0v 1839.45n 5.0v 1839.55n 5.0v 1849.45n 5.0v 1849.55n 5.0v 1859.45n 5.0v 1859.55n 5.0v 1869.45n 5.0v 1869.55n 5.0v 1879.45n 5.0v 1879.55n 5.0v 1889.45n 5.0v 1889.55n 5.0v 1899.45n 5.0v 1899.55n 5.0v 1909.45n 5.0v 1909.55n 5.0v 1919.45n 5.0v 1919.55n 5.0v 1929.45n 5.0v 1929.55n 5.0v 1939.45n 5.0v 1939.55n 5.0v 1949.45n 5.0v 1949.55n 5.0v 1959.45n 5.0v 1959.55n 5.0v 1969.45n 5.0v 1969.55n 5.0v 1979.45n 5.0v 1979.55n 5.0v 1989.45n 5.0v 1989.55n 5.0v 1999.45n 5.0v 1999.55n 5.0v 2009.45n 5.0v 2009.55n 5.0v 2019.45n 5.0v 2019.55n 5.0v 2029.45n 5.0v 2029.55n 5.0v 2039.45n 5.0v 2039.55n 5.0v 2049.45n 5.0v 2049.55n 5.0v )
* (time, data): [(0, 0), (10, 0), (20, 1), (30, 0), (40, 0), (50, 0), (60, 0), (70, 0), (80, 0), (90, 0), (100, 0), (110, 0), (120, 1), (130, 1), (140, 1), (150, 1), (160, 1), (170, 0), (180, 1), (190, 1), (200, 1), (210, 1), (220, 1), (230, 1), (240, 1), (250, 1), (260, 1), (270, 1), (280, 1), (290, 0), (300, 0), (310, 0), (320, 0), (330, 0), (340, 0), (350, 0), (360, 1), (370, 1), (380, 1), (390, 1), (400, 1), (410, 1), (420, 0), (430, 0), (440, 0), (450, 1), (460, 1), (470, 1), (480, 1), (490, 1), (500, 1), (510, 1), (520, 1), (530, 1), (540, 1), (550, 1), (560, 1), (570, 1), (580, 1), (590, 1), (600, 1), (610, 1), (620, 1), (630, 1), (640, 1), (650, 0), (660, 0), (670, 0), (680, 0), (690, 0), (700, 1), (710, 1), (720, 1), (730, 1), (740, 1), (750, 0), (760, 0), (770, 0), (780, 0), (790, 0), (800, 0), (810, 0), (820, 0), (830, 0), (840, 1), (850, 1), (860, 1), (870, 1), (880, 0), (890, 0), (900, 0), (910, 0), (920, 0), (930, 0), (940, 1), (950, 0), (960, 0), (970, 0), (980, 0), (990, 0), (1000, 0), (1010, 0), (1020, 0), (1030, 1), (1040, 0), (1050, 0), (1060, 0), (1070, 1), (1080, 1), (1090, 1), (1100, 1), (1110, 1), (1120, 1), (1130, 1), (1140, 1), (1150, 1), (1160, 0), (1170, 0), (1180, 0), (1190, 0), (1200, 0), (1210, 0), (1220, 1), (1230, 1), (1240, 1), (1250, 1), (1260, 1), (1270, 1), (1280, 0), (1290, 1), (1300, 1), (1310, 1), (1320, 1), (1330, 1), (1340, 1), (1350, 1), (1360, 1), (1370, 1), (1380, 1), (1390, 1), (1400, 0), (1410, 0), (1420, 0), (1430, 0), (1440, 0), (1450, 0), (1460, 0), (1470, 0), (1480, 0), (1490, 0), (1500, 0), (1510, 0), (1520, 0), (1530, 0), (1540, 0), (1550, 0), (1560, 0), (1570, 0), (1580, 0), (1590, 0), (1600, 0), (1610, 0), (1620, 0), (1630, 0), (1640, 0), (1650, 0), (1660, 0), (1670, 0), (1680, 0), (1690, 0), (1700, 0), (1710, 0), (1720, 1), (1730, 0), (1740, 1), (1750, 1), (1760, 1), (1770, 1), (1780, 1), (1790, 1), (1800, 1), (1810, 1), (1820, 1), (1830, 1), (1840, 1), (1850, 0), (1860, 0), (1870, 0), (1880, 0), (1890, 0), (1900, 0), (1910, 0), (1920, 0), (1930, 0), (1940, 0), (1950, 0), (1960, 0), (1970, 0), (1980, 0), (1990, 0), (2000, 0), (2010, 0), (2020, 0), (2030, 0), (2040, 0), (2050, 0)]
Vdin0_1  din0_1  0 PWL (0n 0.0v 9.45n 0.0v 9.55n 0.0v 19.45n 0.0v 19.55n 5.0v 29.45n 5.0v 29.55n 0.0v 39.45n 0.0v 39.55n 0.0v 49.45n 0.0v 49.55n 0.0v 59.45n 0.0v 59.55n 0.0v 69.45n 0.0v 69.55n 0.0v 79.45n 0.0v 79.55n 0.0v 89.45n 0.0v 89.55n 0.0v 99.45n 0.0v 99.55n 0.0v 109.45n 0.0v 109.55n 0.0v 119.45n 0.0v 119.55n 5.0v 129.45n 5.0v 129.55n 5.0v 139.45n 5.0v 139.55n 5.0v 149.45n 5.0v 149.55n 5.0v 159.45n 5.0v 159.55n 5.0v 169.45n 5.0v 169.55n 0.0v 179.45n 0.0v 179.55n 5.0v 189.45n 5.0v 189.55n 5.0v 199.45n 5.0v 199.55n 5.0v 209.45n 5.0v 209.55n 5.0v 219.45n 5.0v 219.55n 5.0v 229.45n 5.0v 229.55n 5.0v 239.45n 5.0v 239.55n 5.0v 249.45n 5.0v 249.55n 5.0v 259.45n 5.0v 259.55n 5.0v 269.45n 5.0v 269.55n 5.0v 279.45n 5.0v 279.55n 5.0v 289.45n 5.0v 289.55n 0.0v 299.45n 0.0v 299.55n 0.0v 309.45n 0.0v 309.55n 0.0v 319.45n 0.0v 319.55n 0.0v 329.45n 0.0v 329.55n 0.0v 339.45n 0.0v 339.55n 0.0v 349.45n 0.0v 349.55n 0.0v 359.45n 0.0v 359.55n 5.0v 369.45n 5.0v 369.55n 5.0v 379.45n 5.0v 379.55n 5.0v 389.45n 5.0v 389.55n 5.0v 399.45n 5.0v 399.55n 5.0v 409.45n 5.0v 409.55n 5.0v 419.45n 5.0v 419.55n 0.0v 429.45n 0.0v 429.55n 0.0v 439.45n 0.0v 439.55n 0.0v 449.45n 0.0v 449.55n 5.0v 459.45n 5.0v 459.55n 5.0v 469.45n 5.0v 469.55n 5.0v 479.45n 5.0v 479.55n 5.0v 489.45n 5.0v 489.55n 5.0v 499.45n 5.0v 499.55n 5.0v 509.45n 5.0v 509.55n 5.0v 519.45n 5.0v 519.55n 5.0v 529.45n 5.0v 529.55n 5.0v 539.45n 5.0v 539.55n 5.0v 549.45n 5.0v 549.55n 5.0v 559.45n 5.0v 559.55n 5.0v 569.45n 5.0v 569.55n 5.0v 579.45n 5.0v 579.55n 5.0v 589.45n 5.0v 589.55n 5.0v 599.45n 5.0v 599.55n 5.0v 609.45n 5.0v 609.55n 5.0v 619.45n 5.0v 619.55n 5.0v 629.45n 5.0v 629.55n 5.0v 639.45n 5.0v 639.55n 5.0v 649.45n 5.0v 649.55n 0.0v 659.45n 0.0v 659.55n 0.0v 669.45n 0.0v 669.55n 0.0v 679.45n 0.0v 679.55n 0.0v 689.45n 0.0v 689.55n 0.0v 699.45n 0.0v 699.55n 5.0v 709.45n 5.0v 709.55n 5.0v 719.45n 5.0v 719.55n 5.0v 729.45n 5.0v 729.55n 5.0v 739.45n 5.0v 739.55n 5.0v 749.45n 5.0v 749.55n 0.0v 759.45n 0.0v 759.55n 0.0v 769.45n 0.0v 769.55n 0.0v 779.45n 0.0v 779.55n 0.0v 789.45n 0.0v 789.55n 0.0v 799.45n 0.0v 799.55n 0.0v 809.45n 0.0v 809.55n 0.0v 819.45n 0.0v 819.55n 0.0v 829.45n 0.0v 829.55n 0.0v 839.45n 0.0v 839.55n 5.0v 849.45n 5.0v 849.55n 5.0v 859.45n 5.0v 859.55n 5.0v 869.45n 5.0v 869.55n 5.0v 879.45n 5.0v 879.55n 0.0v 889.45n 0.0v 889.55n 0.0v 899.45n 0.0v 899.55n 0.0v 909.45n 0.0v 909.55n 0.0v 919.45n 0.0v 919.55n 0.0v 929.45n 0.0v 929.55n 0.0v 939.45n 0.0v 939.55n 5.0v 949.45n 5.0v 949.55n 0.0v 959.45n 0.0v 959.55n 0.0v 969.45n 0.0v 969.55n 0.0v 979.45n 0.0v 979.55n 0.0v 989.45n 0.0v 989.55n 0.0v 999.45n 0.0v 999.55n 0.0v 1009.45n 0.0v 1009.55n 0.0v 1019.45n 0.0v 1019.55n 0.0v 1029.45n 0.0v 1029.55n 5.0v 1039.45n 5.0v 1039.55n 0.0v 1049.45n 0.0v 1049.55n 0.0v 1059.45n 0.0v 1059.55n 0.0v 1069.45n 0.0v 1069.55n 5.0v 1079.45n 5.0v 1079.55n 5.0v 1089.45n 5.0v 1089.55n 5.0v 1099.45n 5.0v 1099.55n 5.0v 1109.45n 5.0v 1109.55n 5.0v 1119.45n 5.0v 1119.55n 5.0v 1129.45n 5.0v 1129.55n 5.0v 1139.45n 5.0v 1139.55n 5.0v 1149.45n 5.0v 1149.55n 5.0v 1159.45n 5.0v 1159.55n 0.0v 1169.45n 0.0v 1169.55n 0.0v 1179.45n 0.0v 1179.55n 0.0v 1189.45n 0.0v 1189.55n 0.0v 1199.45n 0.0v 1199.55n 0.0v 1209.45n 0.0v 1209.55n 0.0v 1219.45n 0.0v 1219.55n 5.0v 1229.45n 5.0v 1229.55n 5.0v 1239.45n 5.0v 1239.55n 5.0v 1249.45n 5.0v 1249.55n 5.0v 1259.45n 5.0v 1259.55n 5.0v 1269.45n 5.0v 1269.55n 5.0v 1279.45n 5.0v 1279.55n 0.0v 1289.45n 0.0v 1289.55n 5.0v 1299.45n 5.0v 1299.55n 5.0v 1309.45n 5.0v 1309.55n 5.0v 1319.45n 5.0v 1319.55n 5.0v 1329.45n 5.0v 1329.55n 5.0v 1339.45n 5.0v 1339.55n 5.0v 1349.45n 5.0v 1349.55n 5.0v 1359.45n 5.0v 1359.55n 5.0v 1369.45n 5.0v 1369.55n 5.0v 1379.45n 5.0v 1379.55n 5.0v 1389.45n 5.0v 1389.55n 5.0v 1399.45n 5.0v 1399.55n 0.0v 1409.45n 0.0v 1409.55n 0.0v 1419.45n 0.0v 1419.55n 0.0v 1429.45n 0.0v 1429.55n 0.0v 1439.45n 0.0v 1439.55n 0.0v 1449.45n 0.0v 1449.55n 0.0v 1459.45n 0.0v 1459.55n 0.0v 1469.45n 0.0v 1469.55n 0.0v 1479.45n 0.0v 1479.55n 0.0v 1489.45n 0.0v 1489.55n 0.0v 1499.45n 0.0v 1499.55n 0.0v 1509.45n 0.0v 1509.55n 0.0v 1519.45n 0.0v 1519.55n 0.0v 1529.45n 0.0v 1529.55n 0.0v 1539.45n 0.0v 1539.55n 0.0v 1549.45n 0.0v 1549.55n 0.0v 1559.45n 0.0v 1559.55n 0.0v 1569.45n 0.0v 1569.55n 0.0v 1579.45n 0.0v 1579.55n 0.0v 1589.45n 0.0v 1589.55n 0.0v 1599.45n 0.0v 1599.55n 0.0v 1609.45n 0.0v 1609.55n 0.0v 1619.45n 0.0v 1619.55n 0.0v 1629.45n 0.0v 1629.55n 0.0v 1639.45n 0.0v 1639.55n 0.0v 1649.45n 0.0v 1649.55n 0.0v 1659.45n 0.0v 1659.55n 0.0v 1669.45n 0.0v 1669.55n 0.0v 1679.45n 0.0v 1679.55n 0.0v 1689.45n 0.0v 1689.55n 0.0v 1699.45n 0.0v 1699.55n 0.0v 1709.45n 0.0v 1709.55n 0.0v 1719.45n 0.0v 1719.55n 5.0v 1729.45n 5.0v 1729.55n 0.0v 1739.45n 0.0v 1739.55n 5.0v 1749.45n 5.0v 1749.55n 5.0v 1759.45n 5.0v 1759.55n 5.0v 1769.45n 5.0v 1769.55n 5.0v 1779.45n 5.0v 1779.55n 5.0v 1789.45n 5.0v 1789.55n 5.0v 1799.45n 5.0v 1799.55n 5.0v 1809.45n 5.0v 1809.55n 5.0v 1819.45n 5.0v 1819.55n 5.0v 1829.45n 5.0v 1829.55n 5.0v 1839.45n 5.0v 1839.55n 5.0v 1849.45n 5.0v 1849.55n 0.0v 1859.45n 0.0v 1859.55n 0.0v 1869.45n 0.0v 1869.55n 0.0v 1879.45n 0.0v 1879.55n 0.0v 1889.45n 0.0v 1889.55n 0.0v 1899.45n 0.0v 1899.55n 0.0v 1909.45n 0.0v 1909.55n 0.0v 1919.45n 0.0v 1919.55n 0.0v 1929.45n 0.0v 1929.55n 0.0v 1939.45n 0.0v 1939.55n 0.0v 1949.45n 0.0v 1949.55n 0.0v 1959.45n 0.0v 1959.55n 0.0v 1969.45n 0.0v 1969.55n 0.0v 1979.45n 0.0v 1979.55n 0.0v 1989.45n 0.0v 1989.55n 0.0v 1999.45n 0.0v 1999.55n 0.0v 2009.45n 0.0v 2009.55n 0.0v 2019.45n 0.0v 2019.55n 0.0v 2029.45n 0.0v 2029.55n 0.0v 2039.45n 0.0v 2039.55n 0.0v 2049.45n 0.0v 2049.55n 0.0v )
* (time, data): [(0, 0), (10, 0), (20, 1), (30, 0), (40, 0), (50, 0), (60, 0), (70, 0), (80, 0), (90, 0), (100, 0), (110, 0), (120, 0), (130, 1), (140, 1), (150, 1), (160, 1), (170, 0), (180, 0), (190, 0), (200, 0), (210, 0), (220, 0), (230, 0), (240, 0), (250, 0), (260, 0), (270, 0), (280, 0), (290, 0), (300, 0), (310, 0), (320, 0), (330, 0), (340, 0), (350, 1), (360, 1), (370, 1), (380, 1), (390, 1), (400, 1), (410, 1), (420, 1), (430, 1), (440, 1), (450, 0), (460, 0), (470, 0), (480, 0), (490, 0), (500, 1), (510, 1), (520, 1), (530, 1), (540, 1), (550, 1), (560, 1), (570, 1), (580, 1), (590, 1), (600, 1), (610, 1), (620, 1), (630, 1), (640, 0), (650, 0), (660, 0), (670, 0), (680, 0), (690, 0), (700, 0), (710, 0), (720, 0), (730, 0), (740, 0), (750, 0), (760, 0), (770, 0), (780, 0), (790, 0), (800, 0), (810, 0), (820, 0), (830, 0), (840, 1), (850, 1), (860, 1), (870, 1), (880, 1), (890, 1), (900, 1), (910, 1), (920, 1), (930, 1), (940, 1), (950, 0), (960, 0), (970, 0), (980, 0), (990, 0), (1000, 0), (1010, 0), (1020, 0), (1030, 1), (1040, 1), (1050, 1), (1060, 1), (1070, 0), (1080, 0), (1090, 0), (1100, 0), (1110, 0), (1120, 0), (1130, 0), (1140, 0), (1150, 0), (1160, 1), (1170, 1), (1180, 0), (1190, 0), (1200, 0), (1210, 0), (1220, 0), (1230, 0), (1240, 0), (1250, 0), (1260, 0), (1270, 0), (1280, 0), (1290, 1), (1300, 1), (1310, 1), (1320, 0), (1330, 0), (1340, 0), (1350, 0), (1360, 0), (1370, 0), (1380, 0), (1390, 0), (1400, 0), (1410, 0), (1420, 0), (1430, 0), (1440, 0), (1450, 0), (1460, 0), (1470, 0), (1480, 0), (1490, 0), (1500, 0), (1510, 0), (1520, 0), (1530, 1), (1540, 1), (1550, 1), (1560, 1), (1570, 1), (1580, 1), (1590, 1), (1600, 1), (1610, 1), (1620, 1), (1630, 1), (1640, 1), (1650, 1), (1660, 1), (1670, 1), (1680, 1), (1690, 1), (1700, 1), (1710, 1), (1720, 0), (1730, 0), (1740, 0), (1750, 0), (1760, 0), (1770, 0), (1780, 0), (1790, 0), (1800, 0), (1810, 1), (1820, 1), (1830, 1), (1840, 1), (1850, 1), (1860, 1), (1870, 1), (1880, 1), (1890, 1), (1900, 1), (1910, 1), (1920, 1), (1930, 1), (1940, 1), (1950, 1), (1960, 1), (1970, 0), (1980, 0), (1990, 0), (2000, 0), (2010, 0), (2020, 0), (2030, 0), (2040, 0), (2050, 0)]
Vdin0_2  din0_2  0 PWL (0n 0.0v 9.45n 0.0v 9.55n 0.0v 19.45n 0.0v 19.55n 5.0v 29.45n 5.0v 29.55n 0.0v 39.45n 0.0v 39.55n 0.0v 49.45n 0.0v 49.55n 0.0v 59.45n 0.0v 59.55n 0.0v 69.45n 0.0v 69.55n 0.0v 79.45n 0.0v 79.55n 0.0v 89.45n 0.0v 89.55n 0.0v 99.45n 0.0v 99.55n 0.0v 109.45n 0.0v 109.55n 0.0v 119.45n 0.0v 119.55n 0.0v 129.45n 0.0v 129.55n 5.0v 139.45n 5.0v 139.55n 5.0v 149.45n 5.0v 149.55n 5.0v 159.45n 5.0v 159.55n 5.0v 169.45n 5.0v 169.55n 0.0v 179.45n 0.0v 179.55n 0.0v 189.45n 0.0v 189.55n 0.0v 199.45n 0.0v 199.55n 0.0v 209.45n 0.0v 209.55n 0.0v 219.45n 0.0v 219.55n 0.0v 229.45n 0.0v 229.55n 0.0v 239.45n 0.0v 239.55n 0.0v 249.45n 0.0v 249.55n 0.0v 259.45n 0.0v 259.55n 0.0v 269.45n 0.0v 269.55n 0.0v 279.45n 0.0v 279.55n 0.0v 289.45n 0.0v 289.55n 0.0v 299.45n 0.0v 299.55n 0.0v 309.45n 0.0v 309.55n 0.0v 319.45n 0.0v 319.55n 0.0v 329.45n 0.0v 329.55n 0.0v 339.45n 0.0v 339.55n 0.0v 349.45n 0.0v 349.55n 5.0v 359.45n 5.0v 359.55n 5.0v 369.45n 5.0v 369.55n 5.0v 379.45n 5.0v 379.55n 5.0v 389.45n 5.0v 389.55n 5.0v 399.45n 5.0v 399.55n 5.0v 409.45n 5.0v 409.55n 5.0v 419.45n 5.0v 419.55n 5.0v 429.45n 5.0v 429.55n 5.0v 439.45n 5.0v 439.55n 5.0v 449.45n 5.0v 449.55n 0.0v 459.45n 0.0v 459.55n 0.0v 469.45n 0.0v 469.55n 0.0v 479.45n 0.0v 479.55n 0.0v 489.45n 0.0v 489.55n 0.0v 499.45n 0.0v 499.55n 5.0v 509.45n 5.0v 509.55n 5.0v 519.45n 5.0v 519.55n 5.0v 529.45n 5.0v 529.55n 5.0v 539.45n 5.0v 539.55n 5.0v 549.45n 5.0v 549.55n 5.0v 559.45n 5.0v 559.55n 5.0v 569.45n 5.0v 569.55n 5.0v 579.45n 5.0v 579.55n 5.0v 589.45n 5.0v 589.55n 5.0v 599.45n 5.0v 599.55n 5.0v 609.45n 5.0v 609.55n 5.0v 619.45n 5.0v 619.55n 5.0v 629.45n 5.0v 629.55n 5.0v 639.45n 5.0v 639.55n 0.0v 649.45n 0.0v 649.55n 0.0v 659.45n 0.0v 659.55n 0.0v 669.45n 0.0v 669.55n 0.0v 679.45n 0.0v 679.55n 0.0v 689.45n 0.0v 689.55n 0.0v 699.45n 0.0v 699.55n 0.0v 709.45n 0.0v 709.55n 0.0v 719.45n 0.0v 719.55n 0.0v 729.45n 0.0v 729.55n 0.0v 739.45n 0.0v 739.55n 0.0v 749.45n 0.0v 749.55n 0.0v 759.45n 0.0v 759.55n 0.0v 769.45n 0.0v 769.55n 0.0v 779.45n 0.0v 779.55n 0.0v 789.45n 0.0v 789.55n 0.0v 799.45n 0.0v 799.55n 0.0v 809.45n 0.0v 809.55n 0.0v 819.45n 0.0v 819.55n 0.0v 829.45n 0.0v 829.55n 0.0v 839.45n 0.0v 839.55n 5.0v 849.45n 5.0v 849.55n 5.0v 859.45n 5.0v 859.55n 5.0v 869.45n 5.0v 869.55n 5.0v 879.45n 5.0v 879.55n 5.0v 889.45n 5.0v 889.55n 5.0v 899.45n 5.0v 899.55n 5.0v 909.45n 5.0v 909.55n 5.0v 919.45n 5.0v 919.55n 5.0v 929.45n 5.0v 929.55n 5.0v 939.45n 5.0v 939.55n 5.0v 949.45n 5.0v 949.55n 0.0v 959.45n 0.0v 959.55n 0.0v 969.45n 0.0v 969.55n 0.0v 979.45n 0.0v 979.55n 0.0v 989.45n 0.0v 989.55n 0.0v 999.45n 0.0v 999.55n 0.0v 1009.45n 0.0v 1009.55n 0.0v 1019.45n 0.0v 1019.55n 0.0v 1029.45n 0.0v 1029.55n 5.0v 1039.45n 5.0v 1039.55n 5.0v 1049.45n 5.0v 1049.55n 5.0v 1059.45n 5.0v 1059.55n 5.0v 1069.45n 5.0v 1069.55n 0.0v 1079.45n 0.0v 1079.55n 0.0v 1089.45n 0.0v 1089.55n 0.0v 1099.45n 0.0v 1099.55n 0.0v 1109.45n 0.0v 1109.55n 0.0v 1119.45n 0.0v 1119.55n 0.0v 1129.45n 0.0v 1129.55n 0.0v 1139.45n 0.0v 1139.55n 0.0v 1149.45n 0.0v 1149.55n 0.0v 1159.45n 0.0v 1159.55n 5.0v 1169.45n 5.0v 1169.55n 5.0v 1179.45n 5.0v 1179.55n 0.0v 1189.45n 0.0v 1189.55n 0.0v 1199.45n 0.0v 1199.55n 0.0v 1209.45n 0.0v 1209.55n 0.0v 1219.45n 0.0v 1219.55n 0.0v 1229.45n 0.0v 1229.55n 0.0v 1239.45n 0.0v 1239.55n 0.0v 1249.45n 0.0v 1249.55n 0.0v 1259.45n 0.0v 1259.55n 0.0v 1269.45n 0.0v 1269.55n 0.0v 1279.45n 0.0v 1279.55n 0.0v 1289.45n 0.0v 1289.55n 5.0v 1299.45n 5.0v 1299.55n 5.0v 1309.45n 5.0v 1309.55n 5.0v 1319.45n 5.0v 1319.55n 0.0v 1329.45n 0.0v 1329.55n 0.0v 1339.45n 0.0v 1339.55n 0.0v 1349.45n 0.0v 1349.55n 0.0v 1359.45n 0.0v 1359.55n 0.0v 1369.45n 0.0v 1369.55n 0.0v 1379.45n 0.0v 1379.55n 0.0v 1389.45n 0.0v 1389.55n 0.0v 1399.45n 0.0v 1399.55n 0.0v 1409.45n 0.0v 1409.55n 0.0v 1419.45n 0.0v 1419.55n 0.0v 1429.45n 0.0v 1429.55n 0.0v 1439.45n 0.0v 1439.55n 0.0v 1449.45n 0.0v 1449.55n 0.0v 1459.45n 0.0v 1459.55n 0.0v 1469.45n 0.0v 1469.55n 0.0v 1479.45n 0.0v 1479.55n 0.0v 1489.45n 0.0v 1489.55n 0.0v 1499.45n 0.0v 1499.55n 0.0v 1509.45n 0.0v 1509.55n 0.0v 1519.45n 0.0v 1519.55n 0.0v 1529.45n 0.0v 1529.55n 5.0v 1539.45n 5.0v 1539.55n 5.0v 1549.45n 5.0v 1549.55n 5.0v 1559.45n 5.0v 1559.55n 5.0v 1569.45n 5.0v 1569.55n 5.0v 1579.45n 5.0v 1579.55n 5.0v 1589.45n 5.0v 1589.55n 5.0v 1599.45n 5.0v 1599.55n 5.0v 1609.45n 5.0v 1609.55n 5.0v 1619.45n 5.0v 1619.55n 5.0v 1629.45n 5.0v 1629.55n 5.0v 1639.45n 5.0v 1639.55n 5.0v 1649.45n 5.0v 1649.55n 5.0v 1659.45n 5.0v 1659.55n 5.0v 1669.45n 5.0v 1669.55n 5.0v 1679.45n 5.0v 1679.55n 5.0v 1689.45n 5.0v 1689.55n 5.0v 1699.45n 5.0v 1699.55n 5.0v 1709.45n 5.0v 1709.55n 5.0v 1719.45n 5.0v 1719.55n 0.0v 1729.45n 0.0v 1729.55n 0.0v 1739.45n 0.0v 1739.55n 0.0v 1749.45n 0.0v 1749.55n 0.0v 1759.45n 0.0v 1759.55n 0.0v 1769.45n 0.0v 1769.55n 0.0v 1779.45n 0.0v 1779.55n 0.0v 1789.45n 0.0v 1789.55n 0.0v 1799.45n 0.0v 1799.55n 0.0v 1809.45n 0.0v 1809.55n 5.0v 1819.45n 5.0v 1819.55n 5.0v 1829.45n 5.0v 1829.55n 5.0v 1839.45n 5.0v 1839.55n 5.0v 1849.45n 5.0v 1849.55n 5.0v 1859.45n 5.0v 1859.55n 5.0v 1869.45n 5.0v 1869.55n 5.0v 1879.45n 5.0v 1879.55n 5.0v 1889.45n 5.0v 1889.55n 5.0v 1899.45n 5.0v 1899.55n 5.0v 1909.45n 5.0v 1909.55n 5.0v 1919.45n 5.0v 1919.55n 5.0v 1929.45n 5.0v 1929.55n 5.0v 1939.45n 5.0v 1939.55n 5.0v 1949.45n 5.0v 1949.55n 5.0v 1959.45n 5.0v 1959.55n 5.0v 1969.45n 5.0v 1969.55n 0.0v 1979.45n 0.0v 1979.55n 0.0v 1989.45n 0.0v 1989.55n 0.0v 1999.45n 0.0v 1999.55n 0.0v 2009.45n 0.0v 2009.55n 0.0v 2019.45n 0.0v 2019.55n 0.0v 2029.45n 0.0v 2029.55n 0.0v 2039.45n 0.0v 2039.55n 0.0v 2049.45n 0.0v 2049.55n 0.0v )
* (time, data): [(0, 0), (10, 1), (20, 1), (30, 1), (40, 1), (50, 1), (60, 1), (70, 1), (80, 1), (90, 1), (100, 1), (110, 1), (120, 1), (130, 1), (140, 1), (150, 1), (160, 1), (170, 1), (180, 0), (190, 0), (200, 0), (210, 0), (220, 0), (230, 0), (240, 0), (250, 0), (260, 0), (270, 0), (280, 0), (290, 1), (300, 0), (310, 0), (320, 0), (330, 0), (340, 0), (350, 0), (360, 1), (370, 1), (380, 1), (390, 1), (400, 1), (410, 1), (420, 1), (430, 1), (440, 1), (450, 0), (460, 0), (470, 0), (480, 0), (490, 0), (500, 0), (510, 0), (520, 0), (530, 0), (540, 0), (550, 0), (560, 0), (570, 0), (580, 0), (590, 0), (600, 0), (610, 0), (620, 0), (630, 0), (640, 1), (650, 1), (660, 1), (670, 1), (680, 1), (690, 1), (700, 1), (710, 1), (720, 1), (730, 1), (740, 1), (750, 1), (760, 1), (770, 1), (780, 1), (790, 1), (800, 1), (810, 1), (820, 1), (830, 1), (840, 1), (850, 1), (860, 1), (870, 1), (880, 0), (890, 0), (900, 0), (910, 0), (920, 0), (930, 0), (940, 1), (950, 0), (960, 0), (970, 0), (980, 0), (990, 0), (1000, 0), (1010, 0), (1020, 0), (1030, 1), (1040, 1), (1050, 1), (1060, 1), (1070, 1), (1080, 1), (1090, 1), (1100, 1), (1110, 1), (1120, 1), (1130, 1), (1140, 1), (1150, 0), (1160, 0), (1170, 0), (1180, 1), (1190, 1), (1200, 1), (1210, 0), (1220, 0), (1230, 0), (1240, 1), (1250, 1), (1260, 1), (1270, 1), (1280, 0), (1290, 1), (1300, 1), (1310, 1), (1320, 0), (1330, 0), (1340, 0), (1350, 0), (1360, 1), (1370, 1), (1380, 1), (1390, 1), (1400, 0), (1410, 0), (1420, 0), (1430, 0), (1440, 0), (1450, 0), (1460, 0), (1470, 0), (1480, 0), (1490, 0), (1500, 0), (1510, 0), (1520, 0), (1530, 0), (1540, 0), (1550, 0), (1560, 0), (1570, 0), (1580, 0), (1590, 0), (1600, 0), (1610, 0), (1620, 0), (1630, 0), (1640, 0), (1650, 0), (1660, 0), (1670, 1), (1680, 1), (1690, 1), (1700, 1), (1710, 1), (1720, 0), (1730, 1), (1740, 0), (1750, 1), (1760, 1), (1770, 1), (1780, 1), (1790, 0), (1800, 0), (1810, 1), (1820, 1), (1830, 1), (1840, 1), (1850, 1), (1860, 1), (1870, 1), (1880, 1), (1890, 1), (1900, 1), (1910, 1), (1920, 1), (1930, 1), (1940, 1), (1950, 1), (1960, 1), (1970, 0), (1980, 0), (1990, 0), (2000, 0), (2010, 0), (2020, 0), (2030, 0), (2040, 0), (2050, 0)]
Vdin0_3  din0_3  0 PWL (0n 0.0v 9.45n 0.0v 9.55n 5.0v 19.45n 5.0v 19.55n 5.0v 29.45n 5.0v 29.55n 5.0v 39.45n 5.0v 39.55n 5.0v 49.45n 5.0v 49.55n 5.0v 59.45n 5.0v 59.55n 5.0v 69.45n 5.0v 69.55n 5.0v 79.45n 5.0v 79.55n 5.0v 89.45n 5.0v 89.55n 5.0v 99.45n 5.0v 99.55n 5.0v 109.45n 5.0v 109.55n 5.0v 119.45n 5.0v 119.55n 5.0v 129.45n 5.0v 129.55n 5.0v 139.45n 5.0v 139.55n 5.0v 149.45n 5.0v 149.55n 5.0v 159.45n 5.0v 159.55n 5.0v 169.45n 5.0v 169.55n 5.0v 179.45n 5.0v 179.55n 0.0v 189.45n 0.0v 189.55n 0.0v 199.45n 0.0v 199.55n 0.0v 209.45n 0.0v 209.55n 0.0v 219.45n 0.0v 219.55n 0.0v 229.45n 0.0v 229.55n 0.0v 239.45n 0.0v 239.55n 0.0v 249.45n 0.0v 249.55n 0.0v 259.45n 0.0v 259.55n 0.0v 269.45n 0.0v 269.55n 0.0v 279.45n 0.0v 279.55n 0.0v 289.45n 0.0v 289.55n 5.0v 299.45n 5.0v 299.55n 0.0v 309.45n 0.0v 309.55n 0.0v 319.45n 0.0v 319.55n 0.0v 329.45n 0.0v 329.55n 0.0v 339.45n 0.0v 339.55n 0.0v 349.45n 0.0v 349.55n 0.0v 359.45n 0.0v 359.55n 5.0v 369.45n 5.0v 369.55n 5.0v 379.45n 5.0v 379.55n 5.0v 389.45n 5.0v 389.55n 5.0v 399.45n 5.0v 399.55n 5.0v 409.45n 5.0v 409.55n 5.0v 419.45n 5.0v 419.55n 5.0v 429.45n 5.0v 429.55n 5.0v 439.45n 5.0v 439.55n 5.0v 449.45n 5.0v 449.55n 0.0v 459.45n 0.0v 459.55n 0.0v 469.45n 0.0v 469.55n 0.0v 479.45n 0.0v 479.55n 0.0v 489.45n 0.0v 489.55n 0.0v 499.45n 0.0v 499.55n 0.0v 509.45n 0.0v 509.55n 0.0v 519.45n 0.0v 519.55n 0.0v 529.45n 0.0v 529.55n 0.0v 539.45n 0.0v 539.55n 0.0v 549.45n 0.0v 549.55n 0.0v 559.45n 0.0v 559.55n 0.0v 569.45n 0.0v 569.55n 0.0v 579.45n 0.0v 579.55n 0.0v 589.45n 0.0v 589.55n 0.0v 599.45n 0.0v 599.55n 0.0v 609.45n 0.0v 609.55n 0.0v 619.45n 0.0v 619.55n 0.0v 629.45n 0.0v 629.55n 0.0v 639.45n 0.0v 639.55n 5.0v 649.45n 5.0v 649.55n 5.0v 659.45n 5.0v 659.55n 5.0v 669.45n 5.0v 669.55n 5.0v 679.45n 5.0v 679.55n 5.0v 689.45n 5.0v 689.55n 5.0v 699.45n 5.0v 699.55n 5.0v 709.45n 5.0v 709.55n 5.0v 719.45n 5.0v 719.55n 5.0v 729.45n 5.0v 729.55n 5.0v 739.45n 5.0v 739.55n 5.0v 749.45n 5.0v 749.55n 5.0v 759.45n 5.0v 759.55n 5.0v 769.45n 5.0v 769.55n 5.0v 779.45n 5.0v 779.55n 5.0v 789.45n 5.0v 789.55n 5.0v 799.45n 5.0v 799.55n 5.0v 809.45n 5.0v 809.55n 5.0v 819.45n 5.0v 819.55n 5.0v 829.45n 5.0v 829.55n 5.0v 839.45n 5.0v 839.55n 5.0v 849.45n 5.0v 849.55n 5.0v 859.45n 5.0v 859.55n 5.0v 869.45n 5.0v 869.55n 5.0v 879.45n 5.0v 879.55n 0.0v 889.45n 0.0v 889.55n 0.0v 899.45n 0.0v 899.55n 0.0v 909.45n 0.0v 909.55n 0.0v 919.45n 0.0v 919.55n 0.0v 929.45n 0.0v 929.55n 0.0v 939.45n 0.0v 939.55n 5.0v 949.45n 5.0v 949.55n 0.0v 959.45n 0.0v 959.55n 0.0v 969.45n 0.0v 969.55n 0.0v 979.45n 0.0v 979.55n 0.0v 989.45n 0.0v 989.55n 0.0v 999.45n 0.0v 999.55n 0.0v 1009.45n 0.0v 1009.55n 0.0v 1019.45n 0.0v 1019.55n 0.0v 1029.45n 0.0v 1029.55n 5.0v 1039.45n 5.0v 1039.55n 5.0v 1049.45n 5.0v 1049.55n 5.0v 1059.45n 5.0v 1059.55n 5.0v 1069.45n 5.0v 1069.55n 5.0v 1079.45n 5.0v 1079.55n 5.0v 1089.45n 5.0v 1089.55n 5.0v 1099.45n 5.0v 1099.55n 5.0v 1109.45n 5.0v 1109.55n 5.0v 1119.45n 5.0v 1119.55n 5.0v 1129.45n 5.0v 1129.55n 5.0v 1139.45n 5.0v 1139.55n 5.0v 1149.45n 5.0v 1149.55n 0.0v 1159.45n 0.0v 1159.55n 0.0v 1169.45n 0.0v 1169.55n 0.0v 1179.45n 0.0v 1179.55n 5.0v 1189.45n 5.0v 1189.55n 5.0v 1199.45n 5.0v 1199.55n 5.0v 1209.45n 5.0v 1209.55n 0.0v 1219.45n 0.0v 1219.55n 0.0v 1229.45n 0.0v 1229.55n 0.0v 1239.45n 0.0v 1239.55n 5.0v 1249.45n 5.0v 1249.55n 5.0v 1259.45n 5.0v 1259.55n 5.0v 1269.45n 5.0v 1269.55n 5.0v 1279.45n 5.0v 1279.55n 0.0v 1289.45n 0.0v 1289.55n 5.0v 1299.45n 5.0v 1299.55n 5.0v 1309.45n 5.0v 1309.55n 5.0v 1319.45n 5.0v 1319.55n 0.0v 1329.45n 0.0v 1329.55n 0.0v 1339.45n 0.0v 1339.55n 0.0v 1349.45n 0.0v 1349.55n 0.0v 1359.45n 0.0v 1359.55n 5.0v 1369.45n 5.0v 1369.55n 5.0v 1379.45n 5.0v 1379.55n 5.0v 1389.45n 5.0v 1389.55n 5.0v 1399.45n 5.0v 1399.55n 0.0v 1409.45n 0.0v 1409.55n 0.0v 1419.45n 0.0v 1419.55n 0.0v 1429.45n 0.0v 1429.55n 0.0v 1439.45n 0.0v 1439.55n 0.0v 1449.45n 0.0v 1449.55n 0.0v 1459.45n 0.0v 1459.55n 0.0v 1469.45n 0.0v 1469.55n 0.0v 1479.45n 0.0v 1479.55n 0.0v 1489.45n 0.0v 1489.55n 0.0v 1499.45n 0.0v 1499.55n 0.0v 1509.45n 0.0v 1509.55n 0.0v 1519.45n 0.0v 1519.55n 0.0v 1529.45n 0.0v 1529.55n 0.0v 1539.45n 0.0v 1539.55n 0.0v 1549.45n 0.0v 1549.55n 0.0v 1559.45n 0.0v 1559.55n 0.0v 1569.45n 0.0v 1569.55n 0.0v 1579.45n 0.0v 1579.55n 0.0v 1589.45n 0.0v 1589.55n 0.0v 1599.45n 0.0v 1599.55n 0.0v 1609.45n 0.0v 1609.55n 0.0v 1619.45n 0.0v 1619.55n 0.0v 1629.45n 0.0v 1629.55n 0.0v 1639.45n 0.0v 1639.55n 0.0v 1649.45n 0.0v 1649.55n 0.0v 1659.45n 0.0v 1659.55n 0.0v 1669.45n 0.0v 1669.55n 5.0v 1679.45n 5.0v 1679.55n 5.0v 1689.45n 5.0v 1689.55n 5.0v 1699.45n 5.0v 1699.55n 5.0v 1709.45n 5.0v 1709.55n 5.0v 1719.45n 5.0v 1719.55n 0.0v 1729.45n 0.0v 1729.55n 5.0v 1739.45n 5.0v 1739.55n 0.0v 1749.45n 0.0v 1749.55n 5.0v 1759.45n 5.0v 1759.55n 5.0v 1769.45n 5.0v 1769.55n 5.0v 1779.45n 5.0v 1779.55n 5.0v 1789.45n 5.0v 1789.55n 0.0v 1799.45n 0.0v 1799.55n 0.0v 1809.45n 0.0v 1809.55n 5.0v 1819.45n 5.0v 1819.55n 5.0v 1829.45n 5.0v 1829.55n 5.0v 1839.45n 5.0v 1839.55n 5.0v 1849.45n 5.0v 1849.55n 5.0v 1859.45n 5.0v 1859.55n 5.0v 1869.45n 5.0v 1869.55n 5.0v 1879.45n 5.0v 1879.55n 5.0v 1889.45n 5.0v 1889.55n 5.0v 1899.45n 5.0v 1899.55n 5.0v 1909.45n 5.0v 1909.55n 5.0v 1919.45n 5.0v 1919.55n 5.0v 1929.45n 5.0v 1929.55n 5.0v 1939.45n 5.0v 1939.55n 5.0v 1949.45n 5.0v 1949.55n 5.0v 1959.45n 5.0v 1959.55n 5.0v 1969.45n 5.0v 1969.55n 0.0v 1979.45n 0.0v 1979.55n 0.0v 1989.45n 0.0v 1989.55n 0.0v 1999.45n 0.0v 1999.55n 0.0v 2009.45n 0.0v 2009.55n 0.0v 2019.45n 0.0v 2019.55n 0.0v 2029.45n 0.0v 2029.55n 0.0v 2039.45n 0.0v 2039.55n 0.0v 2049.45n 0.0v 2049.55n 0.0v )
* (time, data): [(0, 0), (10, 1), (20, 1), (30, 0), (40, 0), (50, 0), (60, 0), (70, 0), (80, 0), (90, 0), (100, 0), (110, 0), (120, 1), (130, 1), (140, 1), (150, 1), (160, 1), (170, 1), (180, 0), (190, 0), (200, 0), (210, 0), (220, 0), (230, 0), (240, 0), (250, 0), (260, 0), (270, 0), (280, 0), (290, 0), (300, 0), (310, 0), (320, 0), (330, 0), (340, 0), (350, 1), (360, 1), (370, 1), (380, 1), (390, 1), (400, 1), (410, 1), (420, 0), (430, 0), (440, 0), (450, 1), (460, 1), (470, 1), (480, 1), (490, 1), (500, 1), (510, 1), (520, 1), (530, 1), (540, 1), (550, 1), (560, 1), (570, 1), (580, 1), (590, 1), (600, 1), (610, 1), (620, 1), (630, 1), (640, 1), (650, 1), (660, 1), (670, 1), (680, 1), (690, 1), (700, 1), (710, 1), (720, 1), (730, 1), (740, 1), (750, 0), (760, 0), (770, 0), (780, 0), (790, 0), (800, 0), (810, 0), (820, 0), (830, 0), (840, 1), (850, 1), (860, 1), (870, 1), (880, 1), (890, 1), (900, 1), (910, 1), (920, 1), (930, 1), (940, 1), (950, 1), (960, 1), (970, 1), (980, 1), (990, 0), (1000, 0), (1010, 0), (1020, 0), (1030, 1), (1040, 0), (1050, 0), (1060, 0), (1070, 0), (1080, 0), (1090, 0), (1100, 0), (1110, 0), (1120, 0), (1130, 0), (1140, 0), (1150, 1), (1160, 0), (1170, 0), (1180, 1), (1190, 1), (1200, 1), (1210, 1), (1220, 0), (1230, 0), (1240, 0), (1250, 0), (1260, 0), (1270, 0), (1280, 1), (1290, 0), (1300, 0), (1310, 0), (1320, 0), (1330, 0), (1340, 0), (1350, 0), (1360, 1), (1370, 1), (1380, 1), (1390, 1), (1400, 1), (1410, 1), (1420, 1), (1430, 1), (1440, 1), (1450, 1), (1460, 1), (1470, 1), (1480, 1), (1490, 1), (1500, 1), (1510, 1), (1520, 1), (1530, 0), (1540, 0), (1550, 0), (1560, 0), (1570, 0), (1580, 0), (1590, 0), (1600, 0), (1610, 0), (1620, 0), (1630, 0), (1640, 0), (1650, 0), (1660, 0), (1670, 1), (1680, 1), (1690, 1), (1700, 1), (1710, 1), (1720, 1), (1730, 1), (1740, 0), (1750, 1), (1760, 1), (1770, 1), (1780, 1), (1790, 1), (1800, 1), (1810, 1), (1820, 1), (1830, 1), (1840, 1), (1850, 0), (1860, 0), (1870, 0), (1880, 0), (1890, 0), (1900, 0), (1910, 0), (1920, 0), (1930, 0), (1940, 0), (1950, 0), (1960, 0), (1970, 1), (1980, 1), (1990, 1), (2000, 1), (2010, 1), (2020, 1), (2030, 1), (2040, 1), (2050, 1)]
Vdin0_4  din0_4  0 PWL (0n 0.0v 9.45n 0.0v 9.55n 5.0v 19.45n 5.0v 19.55n 5.0v 29.45n 5.0v 29.55n 0.0v 39.45n 0.0v 39.55n 0.0v 49.45n 0.0v 49.55n 0.0v 59.45n 0.0v 59.55n 0.0v 69.45n 0.0v 69.55n 0.0v 79.45n 0.0v 79.55n 0.0v 89.45n 0.0v 89.55n 0.0v 99.45n 0.0v 99.55n 0.0v 109.45n 0.0v 109.55n 0.0v 119.45n 0.0v 119.55n 5.0v 129.45n 5.0v 129.55n 5.0v 139.45n 5.0v 139.55n 5.0v 149.45n 5.0v 149.55n 5.0v 159.45n 5.0v 159.55n 5.0v 169.45n 5.0v 169.55n 5.0v 179.45n 5.0v 179.55n 0.0v 189.45n 0.0v 189.55n 0.0v 199.45n 0.0v 199.55n 0.0v 209.45n 0.0v 209.55n 0.0v 219.45n 0.0v 219.55n 0.0v 229.45n 0.0v 229.55n 0.0v 239.45n 0.0v 239.55n 0.0v 249.45n 0.0v 249.55n 0.0v 259.45n 0.0v 259.55n 0.0v 269.45n 0.0v 269.55n 0.0v 279.45n 0.0v 279.55n 0.0v 289.45n 0.0v 289.55n 0.0v 299.45n 0.0v 299.55n 0.0v 309.45n 0.0v 309.55n 0.0v 319.45n 0.0v 319.55n 0.0v 329.45n 0.0v 329.55n 0.0v 339.45n 0.0v 339.55n 0.0v 349.45n 0.0v 349.55n 5.0v 359.45n 5.0v 359.55n 5.0v 369.45n 5.0v 369.55n 5.0v 379.45n 5.0v 379.55n 5.0v 389.45n 5.0v 389.55n 5.0v 399.45n 5.0v 399.55n 5.0v 409.45n 5.0v 409.55n 5.0v 419.45n 5.0v 419.55n 0.0v 429.45n 0.0v 429.55n 0.0v 439.45n 0.0v 439.55n 0.0v 449.45n 0.0v 449.55n 5.0v 459.45n 5.0v 459.55n 5.0v 469.45n 5.0v 469.55n 5.0v 479.45n 5.0v 479.55n 5.0v 489.45n 5.0v 489.55n 5.0v 499.45n 5.0v 499.55n 5.0v 509.45n 5.0v 509.55n 5.0v 519.45n 5.0v 519.55n 5.0v 529.45n 5.0v 529.55n 5.0v 539.45n 5.0v 539.55n 5.0v 549.45n 5.0v 549.55n 5.0v 559.45n 5.0v 559.55n 5.0v 569.45n 5.0v 569.55n 5.0v 579.45n 5.0v 579.55n 5.0v 589.45n 5.0v 589.55n 5.0v 599.45n 5.0v 599.55n 5.0v 609.45n 5.0v 609.55n 5.0v 619.45n 5.0v 619.55n 5.0v 629.45n 5.0v 629.55n 5.0v 639.45n 5.0v 639.55n 5.0v 649.45n 5.0v 649.55n 5.0v 659.45n 5.0v 659.55n 5.0v 669.45n 5.0v 669.55n 5.0v 679.45n 5.0v 679.55n 5.0v 689.45n 5.0v 689.55n 5.0v 699.45n 5.0v 699.55n 5.0v 709.45n 5.0v 709.55n 5.0v 719.45n 5.0v 719.55n 5.0v 729.45n 5.0v 729.55n 5.0v 739.45n 5.0v 739.55n 5.0v 749.45n 5.0v 749.55n 0.0v 759.45n 0.0v 759.55n 0.0v 769.45n 0.0v 769.55n 0.0v 779.45n 0.0v 779.55n 0.0v 789.45n 0.0v 789.55n 0.0v 799.45n 0.0v 799.55n 0.0v 809.45n 0.0v 809.55n 0.0v 819.45n 0.0v 819.55n 0.0v 829.45n 0.0v 829.55n 0.0v 839.45n 0.0v 839.55n 5.0v 849.45n 5.0v 849.55n 5.0v 859.45n 5.0v 859.55n 5.0v 869.45n 5.0v 869.55n 5.0v 879.45n 5.0v 879.55n 5.0v 889.45n 5.0v 889.55n 5.0v 899.45n 5.0v 899.55n 5.0v 909.45n 5.0v 909.55n 5.0v 919.45n 5.0v 919.55n 5.0v 929.45n 5.0v 929.55n 5.0v 939.45n 5.0v 939.55n 5.0v 949.45n 5.0v 949.55n 5.0v 959.45n 5.0v 959.55n 5.0v 969.45n 5.0v 969.55n 5.0v 979.45n 5.0v 979.55n 5.0v 989.45n 5.0v 989.55n 0.0v 999.45n 0.0v 999.55n 0.0v 1009.45n 0.0v 1009.55n 0.0v 1019.45n 0.0v 1019.55n 0.0v 1029.45n 0.0v 1029.55n 5.0v 1039.45n 5.0v 1039.55n 0.0v 1049.45n 0.0v 1049.55n 0.0v 1059.45n 0.0v 1059.55n 0.0v 1069.45n 0.0v 1069.55n 0.0v 1079.45n 0.0v 1079.55n 0.0v 1089.45n 0.0v 1089.55n 0.0v 1099.45n 0.0v 1099.55n 0.0v 1109.45n 0.0v 1109.55n 0.0v 1119.45n 0.0v 1119.55n 0.0v 1129.45n 0.0v 1129.55n 0.0v 1139.45n 0.0v 1139.55n 0.0v 1149.45n 0.0v 1149.55n 5.0v 1159.45n 5.0v 1159.55n 0.0v 1169.45n 0.0v 1169.55n 0.0v 1179.45n 0.0v 1179.55n 5.0v 1189.45n 5.0v 1189.55n 5.0v 1199.45n 5.0v 1199.55n 5.0v 1209.45n 5.0v 1209.55n 5.0v 1219.45n 5.0v 1219.55n 0.0v 1229.45n 0.0v 1229.55n 0.0v 1239.45n 0.0v 1239.55n 0.0v 1249.45n 0.0v 1249.55n 0.0v 1259.45n 0.0v 1259.55n 0.0v 1269.45n 0.0v 1269.55n 0.0v 1279.45n 0.0v 1279.55n 5.0v 1289.45n 5.0v 1289.55n 0.0v 1299.45n 0.0v 1299.55n 0.0v 1309.45n 0.0v 1309.55n 0.0v 1319.45n 0.0v 1319.55n 0.0v 1329.45n 0.0v 1329.55n 0.0v 1339.45n 0.0v 1339.55n 0.0v 1349.45n 0.0v 1349.55n 0.0v 1359.45n 0.0v 1359.55n 5.0v 1369.45n 5.0v 1369.55n 5.0v 1379.45n 5.0v 1379.55n 5.0v 1389.45n 5.0v 1389.55n 5.0v 1399.45n 5.0v 1399.55n 5.0v 1409.45n 5.0v 1409.55n 5.0v 1419.45n 5.0v 1419.55n 5.0v 1429.45n 5.0v 1429.55n 5.0v 1439.45n 5.0v 1439.55n 5.0v 1449.45n 5.0v 1449.55n 5.0v 1459.45n 5.0v 1459.55n 5.0v 1469.45n 5.0v 1469.55n 5.0v 1479.45n 5.0v 1479.55n 5.0v 1489.45n 5.0v 1489.55n 5.0v 1499.45n 5.0v 1499.55n 5.0v 1509.45n 5.0v 1509.55n 5.0v 1519.45n 5.0v 1519.55n 5.0v 1529.45n 5.0v 1529.55n 0.0v 1539.45n 0.0v 1539.55n 0.0v 1549.45n 0.0v 1549.55n 0.0v 1559.45n 0.0v 1559.55n 0.0v 1569.45n 0.0v 1569.55n 0.0v 1579.45n 0.0v 1579.55n 0.0v 1589.45n 0.0v 1589.55n 0.0v 1599.45n 0.0v 1599.55n 0.0v 1609.45n 0.0v 1609.55n 0.0v 1619.45n 0.0v 1619.55n 0.0v 1629.45n 0.0v 1629.55n 0.0v 1639.45n 0.0v 1639.55n 0.0v 1649.45n 0.0v 1649.55n 0.0v 1659.45n 0.0v 1659.55n 0.0v 1669.45n 0.0v 1669.55n 5.0v 1679.45n 5.0v 1679.55n 5.0v 1689.45n 5.0v 1689.55n 5.0v 1699.45n 5.0v 1699.55n 5.0v 1709.45n 5.0v 1709.55n 5.0v 1719.45n 5.0v 1719.55n 5.0v 1729.45n 5.0v 1729.55n 5.0v 1739.45n 5.0v 1739.55n 0.0v 1749.45n 0.0v 1749.55n 5.0v 1759.45n 5.0v 1759.55n 5.0v 1769.45n 5.0v 1769.55n 5.0v 1779.45n 5.0v 1779.55n 5.0v 1789.45n 5.0v 1789.55n 5.0v 1799.45n 5.0v 1799.55n 5.0v 1809.45n 5.0v 1809.55n 5.0v 1819.45n 5.0v 1819.55n 5.0v 1829.45n 5.0v 1829.55n 5.0v 1839.45n 5.0v 1839.55n 5.0v 1849.45n 5.0v 1849.55n 0.0v 1859.45n 0.0v 1859.55n 0.0v 1869.45n 0.0v 1869.55n 0.0v 1879.45n 0.0v 1879.55n 0.0v 1889.45n 0.0v 1889.55n 0.0v 1899.45n 0.0v 1899.55n 0.0v 1909.45n 0.0v 1909.55n 0.0v 1919.45n 0.0v 1919.55n 0.0v 1929.45n 0.0v 1929.55n 0.0v 1939.45n 0.0v 1939.55n 0.0v 1949.45n 0.0v 1949.55n 0.0v 1959.45n 0.0v 1959.55n 0.0v 1969.45n 0.0v 1969.55n 5.0v 1979.45n 5.0v 1979.55n 5.0v 1989.45n 5.0v 1989.55n 5.0v 1999.45n 5.0v 1999.55n 5.0v 2009.45n 5.0v 2009.55n 5.0v 2019.45n 5.0v 2019.55n 5.0v 2029.45n 5.0v 2029.55n 5.0v 2039.45n 5.0v 2039.55n 5.0v 2049.45n 5.0v 2049.55n 5.0v )
* (time, data): [(0, 0), (10, 1), (20, 1), (30, 0), (40, 0), (50, 0), (60, 0), (70, 0), (80, 0), (90, 0), (100, 0), (110, 0), (120, 0), (130, 0), (140, 0), (150, 0), (160, 0), (170, 1), (180, 0), (190, 0), (200, 0), (210, 0), (220, 0), (230, 0), (240, 0), (250, 0), (260, 0), (270, 0), (280, 0), (290, 1), (300, 1), (310, 1), (320, 1), (330, 1), (340, 1), (350, 1), (360, 1), (370, 1), (380, 1), (390, 1), (400, 1), (410, 1), (420, 0), (430, 0), (440, 0), (450, 0), (460, 0), (470, 0), (480, 0), (490, 0), (500, 1), (510, 1), (520, 1), (530, 1), (540, 1), (550, 1), (560, 1), (570, 1), (580, 1), (590, 1), (600, 1), (610, 1), (620, 1), (630, 1), (640, 1), (650, 1), (660, 1), (670, 1), (680, 1), (690, 1), (700, 1), (710, 1), (720, 1), (730, 1), (740, 1), (750, 0), (760, 0), (770, 0), (780, 0), (790, 0), (800, 0), (810, 0), (820, 0), (830, 0), (840, 0), (850, 0), (860, 0), (870, 0), (880, 1), (890, 1), (900, 1), (910, 1), (920, 1), (930, 1), (940, 0), (950, 1), (960, 1), (970, 1), (980, 1), (990, 0), (1000, 0), (1010, 0), (1020, 0), (1030, 0), (1040, 0), (1050, 0), (1060, 0), (1070, 1), (1080, 1), (1090, 1), (1100, 1), (1110, 1), (1120, 1), (1130, 1), (1140, 1), (1150, 0), (1160, 0), (1170, 0), (1180, 0), (1190, 0), (1200, 0), (1210, 1), (1220, 0), (1230, 0), (1240, 0), (1250, 0), (1260, 0), (1270, 0), (1280, 0), (1290, 0), (1300, 0), (1310, 0), (1320, 0), (1330, 0), (1340, 0), (1350, 0), (1360, 1), (1370, 1), (1380, 1), (1390, 1), (1400, 0), (1410, 0), (1420, 0), (1430, 0), (1440, 0), (1450, 0), (1460, 0), (1470, 0), (1480, 0), (1490, 0), (1500, 0), (1510, 0), (1520, 0), (1530, 1), (1540, 1), (1550, 1), (1560, 1), (1570, 1), (1580, 1), (1590, 1), (1600, 1), (1610, 1), (1620, 1), (1630, 1), (1640, 1), (1650, 1), (1660, 1), (1670, 1), (1680, 1), (1690, 1), (1700, 1), (1710, 1), (1720, 1), (1730, 1), (1740, 0), (1750, 0), (1760, 0), (1770, 0), (1780, 0), (1790, 1), (1800, 1), (1810, 0), (1820, 0), (1830, 0), (1840, 0), (1850, 0), (1860, 0), (1870, 0), (1880, 0), (1890, 0), (1900, 0), (1910, 0), (1920, 0), (1930, 0), (1940, 0), (1950, 0), (1960, 0), (1970, 0), (1980, 0), (1990, 0), (2000, 0), (2010, 0), (2020, 0), (2030, 0), (2040, 0), (2050, 0)]
Vdin0_5  din0_5  0 PWL (0n 0.0v 9.45n 0.0v 9.55n 5.0v 19.45n 5.0v 19.55n 5.0v 29.45n 5.0v 29.55n 0.0v 39.45n 0.0v 39.55n 0.0v 49.45n 0.0v 49.55n 0.0v 59.45n 0.0v 59.55n 0.0v 69.45n 0.0v 69.55n 0.0v 79.45n 0.0v 79.55n 0.0v 89.45n 0.0v 89.55n 0.0v 99.45n 0.0v 99.55n 0.0v 109.45n 0.0v 109.55n 0.0v 119.45n 0.0v 119.55n 0.0v 129.45n 0.0v 129.55n 0.0v 139.45n 0.0v 139.55n 0.0v 149.45n 0.0v 149.55n 0.0v 159.45n 0.0v 159.55n 0.0v 169.45n 0.0v 169.55n 5.0v 179.45n 5.0v 179.55n 0.0v 189.45n 0.0v 189.55n 0.0v 199.45n 0.0v 199.55n 0.0v 209.45n 0.0v 209.55n 0.0v 219.45n 0.0v 219.55n 0.0v 229.45n 0.0v 229.55n 0.0v 239.45n 0.0v 239.55n 0.0v 249.45n 0.0v 249.55n 0.0v 259.45n 0.0v 259.55n 0.0v 269.45n 0.0v 269.55n 0.0v 279.45n 0.0v 279.55n 0.0v 289.45n 0.0v 289.55n 5.0v 299.45n 5.0v 299.55n 5.0v 309.45n 5.0v 309.55n 5.0v 319.45n 5.0v 319.55n 5.0v 329.45n 5.0v 329.55n 5.0v 339.45n 5.0v 339.55n 5.0v 349.45n 5.0v 349.55n 5.0v 359.45n 5.0v 359.55n 5.0v 369.45n 5.0v 369.55n 5.0v 379.45n 5.0v 379.55n 5.0v 389.45n 5.0v 389.55n 5.0v 399.45n 5.0v 399.55n 5.0v 409.45n 5.0v 409.55n 5.0v 419.45n 5.0v 419.55n 0.0v 429.45n 0.0v 429.55n 0.0v 439.45n 0.0v 439.55n 0.0v 449.45n 0.0v 449.55n 0.0v 459.45n 0.0v 459.55n 0.0v 469.45n 0.0v 469.55n 0.0v 479.45n 0.0v 479.55n 0.0v 489.45n 0.0v 489.55n 0.0v 499.45n 0.0v 499.55n 5.0v 509.45n 5.0v 509.55n 5.0v 519.45n 5.0v 519.55n 5.0v 529.45n 5.0v 529.55n 5.0v 539.45n 5.0v 539.55n 5.0v 549.45n 5.0v 549.55n 5.0v 559.45n 5.0v 559.55n 5.0v 569.45n 5.0v 569.55n 5.0v 579.45n 5.0v 579.55n 5.0v 589.45n 5.0v 589.55n 5.0v 599.45n 5.0v 599.55n 5.0v 609.45n 5.0v 609.55n 5.0v 619.45n 5.0v 619.55n 5.0v 629.45n 5.0v 629.55n 5.0v 639.45n 5.0v 639.55n 5.0v 649.45n 5.0v 649.55n 5.0v 659.45n 5.0v 659.55n 5.0v 669.45n 5.0v 669.55n 5.0v 679.45n 5.0v 679.55n 5.0v 689.45n 5.0v 689.55n 5.0v 699.45n 5.0v 699.55n 5.0v 709.45n 5.0v 709.55n 5.0v 719.45n 5.0v 719.55n 5.0v 729.45n 5.0v 729.55n 5.0v 739.45n 5.0v 739.55n 5.0v 749.45n 5.0v 749.55n 0.0v 759.45n 0.0v 759.55n 0.0v 769.45n 0.0v 769.55n 0.0v 779.45n 0.0v 779.55n 0.0v 789.45n 0.0v 789.55n 0.0v 799.45n 0.0v 799.55n 0.0v 809.45n 0.0v 809.55n 0.0v 819.45n 0.0v 819.55n 0.0v 829.45n 0.0v 829.55n 0.0v 839.45n 0.0v 839.55n 0.0v 849.45n 0.0v 849.55n 0.0v 859.45n 0.0v 859.55n 0.0v 869.45n 0.0v 869.55n 0.0v 879.45n 0.0v 879.55n 5.0v 889.45n 5.0v 889.55n 5.0v 899.45n 5.0v 899.55n 5.0v 909.45n 5.0v 909.55n 5.0v 919.45n 5.0v 919.55n 5.0v 929.45n 5.0v 929.55n 5.0v 939.45n 5.0v 939.55n 0.0v 949.45n 0.0v 949.55n 5.0v 959.45n 5.0v 959.55n 5.0v 969.45n 5.0v 969.55n 5.0v 979.45n 5.0v 979.55n 5.0v 989.45n 5.0v 989.55n 0.0v 999.45n 0.0v 999.55n 0.0v 1009.45n 0.0v 1009.55n 0.0v 1019.45n 0.0v 1019.55n 0.0v 1029.45n 0.0v 1029.55n 0.0v 1039.45n 0.0v 1039.55n 0.0v 1049.45n 0.0v 1049.55n 0.0v 1059.45n 0.0v 1059.55n 0.0v 1069.45n 0.0v 1069.55n 5.0v 1079.45n 5.0v 1079.55n 5.0v 1089.45n 5.0v 1089.55n 5.0v 1099.45n 5.0v 1099.55n 5.0v 1109.45n 5.0v 1109.55n 5.0v 1119.45n 5.0v 1119.55n 5.0v 1129.45n 5.0v 1129.55n 5.0v 1139.45n 5.0v 1139.55n 5.0v 1149.45n 5.0v 1149.55n 0.0v 1159.45n 0.0v 1159.55n 0.0v 1169.45n 0.0v 1169.55n 0.0v 1179.45n 0.0v 1179.55n 0.0v 1189.45n 0.0v 1189.55n 0.0v 1199.45n 0.0v 1199.55n 0.0v 1209.45n 0.0v 1209.55n 5.0v 1219.45n 5.0v 1219.55n 0.0v 1229.45n 0.0v 1229.55n 0.0v 1239.45n 0.0v 1239.55n 0.0v 1249.45n 0.0v 1249.55n 0.0v 1259.45n 0.0v 1259.55n 0.0v 1269.45n 0.0v 1269.55n 0.0v 1279.45n 0.0v 1279.55n 0.0v 1289.45n 0.0v 1289.55n 0.0v 1299.45n 0.0v 1299.55n 0.0v 1309.45n 0.0v 1309.55n 0.0v 1319.45n 0.0v 1319.55n 0.0v 1329.45n 0.0v 1329.55n 0.0v 1339.45n 0.0v 1339.55n 0.0v 1349.45n 0.0v 1349.55n 0.0v 1359.45n 0.0v 1359.55n 5.0v 1369.45n 5.0v 1369.55n 5.0v 1379.45n 5.0v 1379.55n 5.0v 1389.45n 5.0v 1389.55n 5.0v 1399.45n 5.0v 1399.55n 0.0v 1409.45n 0.0v 1409.55n 0.0v 1419.45n 0.0v 1419.55n 0.0v 1429.45n 0.0v 1429.55n 0.0v 1439.45n 0.0v 1439.55n 0.0v 1449.45n 0.0v 1449.55n 0.0v 1459.45n 0.0v 1459.55n 0.0v 1469.45n 0.0v 1469.55n 0.0v 1479.45n 0.0v 1479.55n 0.0v 1489.45n 0.0v 1489.55n 0.0v 1499.45n 0.0v 1499.55n 0.0v 1509.45n 0.0v 1509.55n 0.0v 1519.45n 0.0v 1519.55n 0.0v 1529.45n 0.0v 1529.55n 5.0v 1539.45n 5.0v 1539.55n 5.0v 1549.45n 5.0v 1549.55n 5.0v 1559.45n 5.0v 1559.55n 5.0v 1569.45n 5.0v 1569.55n 5.0v 1579.45n 5.0v 1579.55n 5.0v 1589.45n 5.0v 1589.55n 5.0v 1599.45n 5.0v 1599.55n 5.0v 1609.45n 5.0v 1609.55n 5.0v 1619.45n 5.0v 1619.55n 5.0v 1629.45n 5.0v 1629.55n 5.0v 1639.45n 5.0v 1639.55n 5.0v 1649.45n 5.0v 1649.55n 5.0v 1659.45n 5.0v 1659.55n 5.0v 1669.45n 5.0v 1669.55n 5.0v 1679.45n 5.0v 1679.55n 5.0v 1689.45n 5.0v 1689.55n 5.0v 1699.45n 5.0v 1699.55n 5.0v 1709.45n 5.0v 1709.55n 5.0v 1719.45n 5.0v 1719.55n 5.0v 1729.45n 5.0v 1729.55n 5.0v 1739.45n 5.0v 1739.55n 0.0v 1749.45n 0.0v 1749.55n 0.0v 1759.45n 0.0v 1759.55n 0.0v 1769.45n 0.0v 1769.55n 0.0v 1779.45n 0.0v 1779.55n 0.0v 1789.45n 0.0v 1789.55n 5.0v 1799.45n 5.0v 1799.55n 5.0v 1809.45n 5.0v 1809.55n 0.0v 1819.45n 0.0v 1819.55n 0.0v 1829.45n 0.0v 1829.55n 0.0v 1839.45n 0.0v 1839.55n 0.0v 1849.45n 0.0v 1849.55n 0.0v 1859.45n 0.0v 1859.55n 0.0v 1869.45n 0.0v 1869.55n 0.0v 1879.45n 0.0v 1879.55n 0.0v 1889.45n 0.0v 1889.55n 0.0v 1899.45n 0.0v 1899.55n 0.0v 1909.45n 0.0v 1909.55n 0.0v 1919.45n 0.0v 1919.55n 0.0v 1929.45n 0.0v 1929.55n 0.0v 1939.45n 0.0v 1939.55n 0.0v 1949.45n 0.0v 1949.55n 0.0v 1959.45n 0.0v 1959.55n 0.0v 1969.45n 0.0v 1969.55n 0.0v 1979.45n 0.0v 1979.55n 0.0v 1989.45n 0.0v 1989.55n 0.0v 1999.45n 0.0v 1999.55n 0.0v 2009.45n 0.0v 2009.55n 0.0v 2019.45n 0.0v 2019.55n 0.0v 2029.45n 0.0v 2029.55n 0.0v 2039.45n 0.0v 2039.55n 0.0v 2049.45n 0.0v 2049.55n 0.0v )
* (time, data): [(0, 0), (10, 0), (20, 0), (30, 1), (40, 1), (50, 1), (60, 1), (70, 1), (80, 1), (90, 1), (100, 1), (110, 1), (120, 0), (130, 0), (140, 0), (150, 0), (160, 0), (170, 0), (180, 1), (190, 1), (200, 1), (210, 1), (220, 1), (230, 1), (240, 1), (250, 1), (260, 1), (270, 1), (280, 1), (290, 1), (300, 0), (310, 0), (320, 0), (330, 0), (340, 0), (350, 0), (360, 0), (370, 0), (380, 0), (390, 0), (400, 0), (410, 0), (420, 1), (430, 1), (440, 1), (450, 0), (460, 0), (470, 0), (480, 0), (490, 0), (500, 1), (510, 1), (520, 1), (530, 1), (540, 1), (550, 1), (560, 1), (570, 1), (580, 1), (590, 1), (600, 1), (610, 1), (620, 1), (630, 1), (640, 0), (650, 1), (660, 1), (670, 1), (680, 1), (690, 1), (700, 0), (710, 0), (720, 0), (730, 0), (740, 0), (750, 0), (760, 0), (770, 0), (780, 0), (790, 0), (800, 0), (810, 0), (820, 0), (830, 0), (840, 0), (850, 0), (860, 0), (870, 0), (880, 0), (890, 0), (900, 0), (910, 0), (920, 0), (930, 0), (940, 1), (950, 1), (960, 1), (970, 1), (980, 1), (990, 1), (1000, 1), (1010, 1), (1020, 1), (1030, 1), (1040, 1), (1050, 1), (1060, 1), (1070, 0), (1080, 0), (1090, 0), (1100, 0), (1110, 0), (1120, 0), (1130, 0), (1140, 0), (1150, 1), (1160, 0), (1170, 0), (1180, 0), (1190, 0), (1200, 0), (1210, 0), (1220, 0), (1230, 0), (1240, 0), (1250, 0), (1260, 0), (1270, 0), (1280, 0), (1290, 1), (1300, 1), (1310, 1), (1320, 0), (1330, 0), (1340, 0), (1350, 0), (1360, 1), (1370, 1), (1380, 1), (1390, 1), (1400, 1), (1410, 1), (1420, 1), (1430, 1), (1440, 1), (1450, 1), (1460, 1), (1470, 1), (1480, 1), (1490, 1), (1500, 1), (1510, 1), (1520, 1), (1530, 1), (1540, 1), (1550, 1), (1560, 1), (1570, 1), (1580, 1), (1590, 1), (1600, 1), (1610, 1), (1620, 1), (1630, 1), (1640, 1), (1650, 1), (1660, 1), (1670, 1), (1680, 1), (1690, 1), (1700, 1), (1710, 1), (1720, 0), (1730, 0), (1740, 1), (1750, 1), (1760, 1), (1770, 1), (1780, 1), (1790, 0), (1800, 0), (1810, 0), (1820, 0), (1830, 0), (1840, 0), (1850, 1), (1860, 1), (1870, 1), (1880, 1), (1890, 1), (1900, 1), (1910, 1), (1920, 1), (1930, 1), (1940, 1), (1950, 1), (1960, 1), (1970, 1), (1980, 1), (1990, 1), (2000, 1), (2010, 1), (2020, 1), (2030, 1), (2040, 1), (2050, 1)]
Vdin0_6  din0_6  0 PWL (0n 0.0v 9.45n 0.0v 9.55n 0.0v 19.45n 0.0v 19.55n 0.0v 29.45n 0.0v 29.55n 5.0v 39.45n 5.0v 39.55n 5.0v 49.45n 5.0v 49.55n 5.0v 59.45n 5.0v 59.55n 5.0v 69.45n 5.0v 69.55n 5.0v 79.45n 5.0v 79.55n 5.0v 89.45n 5.0v 89.55n 5.0v 99.45n 5.0v 99.55n 5.0v 109.45n 5.0v 109.55n 5.0v 119.45n 5.0v 119.55n 0.0v 129.45n 0.0v 129.55n 0.0v 139.45n 0.0v 139.55n 0.0v 149.45n 0.0v 149.55n 0.0v 159.45n 0.0v 159.55n 0.0v 169.45n 0.0v 169.55n 0.0v 179.45n 0.0v 179.55n 5.0v 189.45n 5.0v 189.55n 5.0v 199.45n 5.0v 199.55n 5.0v 209.45n 5.0v 209.55n 5.0v 219.45n 5.0v 219.55n 5.0v 229.45n 5.0v 229.55n 5.0v 239.45n 5.0v 239.55n 5.0v 249.45n 5.0v 249.55n 5.0v 259.45n 5.0v 259.55n 5.0v 269.45n 5.0v 269.55n 5.0v 279.45n 5.0v 279.55n 5.0v 289.45n 5.0v 289.55n 5.0v 299.45n 5.0v 299.55n 0.0v 309.45n 0.0v 309.55n 0.0v 319.45n 0.0v 319.55n 0.0v 329.45n 0.0v 329.55n 0.0v 339.45n 0.0v 339.55n 0.0v 349.45n 0.0v 349.55n 0.0v 359.45n 0.0v 359.55n 0.0v 369.45n 0.0v 369.55n 0.0v 379.45n 0.0v 379.55n 0.0v 389.45n 0.0v 389.55n 0.0v 399.45n 0.0v 399.55n 0.0v 409.45n 0.0v 409.55n 0.0v 419.45n 0.0v 419.55n 5.0v 429.45n 5.0v 429.55n 5.0v 439.45n 5.0v 439.55n 5.0v 449.45n 5.0v 449.55n 0.0v 459.45n 0.0v 459.55n 0.0v 469.45n 0.0v 469.55n 0.0v 479.45n 0.0v 479.55n 0.0v 489.45n 0.0v 489.55n 0.0v 499.45n 0.0v 499.55n 5.0v 509.45n 5.0v 509.55n 5.0v 519.45n 5.0v 519.55n 5.0v 529.45n 5.0v 529.55n 5.0v 539.45n 5.0v 539.55n 5.0v 549.45n 5.0v 549.55n 5.0v 559.45n 5.0v 559.55n 5.0v 569.45n 5.0v 569.55n 5.0v 579.45n 5.0v 579.55n 5.0v 589.45n 5.0v 589.55n 5.0v 599.45n 5.0v 599.55n 5.0v 609.45n 5.0v 609.55n 5.0v 619.45n 5.0v 619.55n 5.0v 629.45n 5.0v 629.55n 5.0v 639.45n 5.0v 639.55n 0.0v 649.45n 0.0v 649.55n 5.0v 659.45n 5.0v 659.55n 5.0v 669.45n 5.0v 669.55n 5.0v 679.45n 5.0v 679.55n 5.0v 689.45n 5.0v 689.55n 5.0v 699.45n 5.0v 699.55n 0.0v 709.45n 0.0v 709.55n 0.0v 719.45n 0.0v 719.55n 0.0v 729.45n 0.0v 729.55n 0.0v 739.45n 0.0v 739.55n 0.0v 749.45n 0.0v 749.55n 0.0v 759.45n 0.0v 759.55n 0.0v 769.45n 0.0v 769.55n 0.0v 779.45n 0.0v 779.55n 0.0v 789.45n 0.0v 789.55n 0.0v 799.45n 0.0v 799.55n 0.0v 809.45n 0.0v 809.55n 0.0v 819.45n 0.0v 819.55n 0.0v 829.45n 0.0v 829.55n 0.0v 839.45n 0.0v 839.55n 0.0v 849.45n 0.0v 849.55n 0.0v 859.45n 0.0v 859.55n 0.0v 869.45n 0.0v 869.55n 0.0v 879.45n 0.0v 879.55n 0.0v 889.45n 0.0v 889.55n 0.0v 899.45n 0.0v 899.55n 0.0v 909.45n 0.0v 909.55n 0.0v 919.45n 0.0v 919.55n 0.0v 929.45n 0.0v 929.55n 0.0v 939.45n 0.0v 939.55n 5.0v 949.45n 5.0v 949.55n 5.0v 959.45n 5.0v 959.55n 5.0v 969.45n 5.0v 969.55n 5.0v 979.45n 5.0v 979.55n 5.0v 989.45n 5.0v 989.55n 5.0v 999.45n 5.0v 999.55n 5.0v 1009.45n 5.0v 1009.55n 5.0v 1019.45n 5.0v 1019.55n 5.0v 1029.45n 5.0v 1029.55n 5.0v 1039.45n 5.0v 1039.55n 5.0v 1049.45n 5.0v 1049.55n 5.0v 1059.45n 5.0v 1059.55n 5.0v 1069.45n 5.0v 1069.55n 0.0v 1079.45n 0.0v 1079.55n 0.0v 1089.45n 0.0v 1089.55n 0.0v 1099.45n 0.0v 1099.55n 0.0v 1109.45n 0.0v 1109.55n 0.0v 1119.45n 0.0v 1119.55n 0.0v 1129.45n 0.0v 1129.55n 0.0v 1139.45n 0.0v 1139.55n 0.0v 1149.45n 0.0v 1149.55n 5.0v 1159.45n 5.0v 1159.55n 0.0v 1169.45n 0.0v 1169.55n 0.0v 1179.45n 0.0v 1179.55n 0.0v 1189.45n 0.0v 1189.55n 0.0v 1199.45n 0.0v 1199.55n 0.0v 1209.45n 0.0v 1209.55n 0.0v 1219.45n 0.0v 1219.55n 0.0v 1229.45n 0.0v 1229.55n 0.0v 1239.45n 0.0v 1239.55n 0.0v 1249.45n 0.0v 1249.55n 0.0v 1259.45n 0.0v 1259.55n 0.0v 1269.45n 0.0v 1269.55n 0.0v 1279.45n 0.0v 1279.55n 0.0v 1289.45n 0.0v 1289.55n 5.0v 1299.45n 5.0v 1299.55n 5.0v 1309.45n 5.0v 1309.55n 5.0v 1319.45n 5.0v 1319.55n 0.0v 1329.45n 0.0v 1329.55n 0.0v 1339.45n 0.0v 1339.55n 0.0v 1349.45n 0.0v 1349.55n 0.0v 1359.45n 0.0v 1359.55n 5.0v 1369.45n 5.0v 1369.55n 5.0v 1379.45n 5.0v 1379.55n 5.0v 1389.45n 5.0v 1389.55n 5.0v 1399.45n 5.0v 1399.55n 5.0v 1409.45n 5.0v 1409.55n 5.0v 1419.45n 5.0v 1419.55n 5.0v 1429.45n 5.0v 1429.55n 5.0v 1439.45n 5.0v 1439.55n 5.0v 1449.45n 5.0v 1449.55n 5.0v 1459.45n 5.0v 1459.55n 5.0v 1469.45n 5.0v 1469.55n 5.0v 1479.45n 5.0v 1479.55n 5.0v 1489.45n 5.0v 1489.55n 5.0v 1499.45n 5.0v 1499.55n 5.0v 1509.45n 5.0v 1509.55n 5.0v 1519.45n 5.0v 1519.55n 5.0v 1529.45n 5.0v 1529.55n 5.0v 1539.45n 5.0v 1539.55n 5.0v 1549.45n 5.0v 1549.55n 5.0v 1559.45n 5.0v 1559.55n 5.0v 1569.45n 5.0v 1569.55n 5.0v 1579.45n 5.0v 1579.55n 5.0v 1589.45n 5.0v 1589.55n 5.0v 1599.45n 5.0v 1599.55n 5.0v 1609.45n 5.0v 1609.55n 5.0v 1619.45n 5.0v 1619.55n 5.0v 1629.45n 5.0v 1629.55n 5.0v 1639.45n 5.0v 1639.55n 5.0v 1649.45n 5.0v 1649.55n 5.0v 1659.45n 5.0v 1659.55n 5.0v 1669.45n 5.0v 1669.55n 5.0v 1679.45n 5.0v 1679.55n 5.0v 1689.45n 5.0v 1689.55n 5.0v 1699.45n 5.0v 1699.55n 5.0v 1709.45n 5.0v 1709.55n 5.0v 1719.45n 5.0v 1719.55n 0.0v 1729.45n 0.0v 1729.55n 0.0v 1739.45n 0.0v 1739.55n 5.0v 1749.45n 5.0v 1749.55n 5.0v 1759.45n 5.0v 1759.55n 5.0v 1769.45n 5.0v 1769.55n 5.0v 1779.45n 5.0v 1779.55n 5.0v 1789.45n 5.0v 1789.55n 0.0v 1799.45n 0.0v 1799.55n 0.0v 1809.45n 0.0v 1809.55n 0.0v 1819.45n 0.0v 1819.55n 0.0v 1829.45n 0.0v 1829.55n 0.0v 1839.45n 0.0v 1839.55n 0.0v 1849.45n 0.0v 1849.55n 5.0v 1859.45n 5.0v 1859.55n 5.0v 1869.45n 5.0v 1869.55n 5.0v 1879.45n 5.0v 1879.55n 5.0v 1889.45n 5.0v 1889.55n 5.0v 1899.45n 5.0v 1899.55n 5.0v 1909.45n 5.0v 1909.55n 5.0v 1919.45n 5.0v 1919.55n 5.0v 1929.45n 5.0v 1929.55n 5.0v 1939.45n 5.0v 1939.55n 5.0v 1949.45n 5.0v 1949.55n 5.0v 1959.45n 5.0v 1959.55n 5.0v 1969.45n 5.0v 1969.55n 5.0v 1979.45n 5.0v 1979.55n 5.0v 1989.45n 5.0v 1989.55n 5.0v 1999.45n 5.0v 1999.55n 5.0v 2009.45n 5.0v 2009.55n 5.0v 2019.45n 5.0v 2019.55n 5.0v 2029.45n 5.0v 2029.55n 5.0v 2039.45n 5.0v 2039.55n 5.0v 2049.45n 5.0v 2049.55n 5.0v )
* (time, data): [(0, 0), (10, 0), (20, 0), (30, 1), (40, 1), (50, 1), (60, 1), (70, 1), (80, 1), (90, 1), (100, 1), (110, 1), (120, 0), (130, 1), (140, 1), (150, 1), (160, 1), (170, 0), (180, 1), (190, 1), (200, 1), (210, 1), (220, 1), (230, 1), (240, 1), (250, 1), (260, 1), (270, 1), (280, 1), (290, 0), (300, 1), (310, 1), (320, 1), (330, 1), (340, 1), (350, 0), (360, 1), (370, 1), (380, 1), (390, 1), (400, 1), (410, 1), (420, 0), (430, 0), (440, 0), (450, 0), (460, 0), (470, 0), (480, 0), (490, 0), (500, 1), (510, 1), (520, 1), (530, 1), (540, 1), (550, 1), (560, 1), (570, 1), (580, 1), (590, 1), (600, 1), (610, 1), (620, 1), (630, 1), (640, 1), (650, 0), (660, 0), (670, 0), (680, 0), (690, 0), (700, 1), (710, 1), (720, 1), (730, 1), (740, 1), (750, 0), (760, 0), (770, 0), (780, 0), (790, 0), (800, 0), (810, 0), (820, 0), (830, 0), (840, 0), (850, 0), (860, 0), (870, 0), (880, 1), (890, 1), (900, 1), (910, 1), (920, 1), (930, 1), (940, 1), (950, 0), (960, 0), (970, 0), (980, 0), (990, 1), (1000, 1), (1010, 1), (1020, 1), (1030, 1), (1040, 0), (1050, 0), (1060, 0), (1070, 1), (1080, 1), (1090, 1), (1100, 1), (1110, 1), (1120, 1), (1130, 1), (1140, 1), (1150, 1), (1160, 1), (1170, 1), (1180, 0), (1190, 0), (1200, 0), (1210, 1), (1220, 0), (1230, 0), (1240, 1), (1250, 1), (1260, 1), (1270, 1), (1280, 0), (1290, 0), (1300, 0), (1310, 0), (1320, 1), (1330, 1), (1340, 1), (1350, 1), (1360, 1), (1370, 1), (1380, 1), (1390, 1), (1400, 1), (1410, 1), (1420, 1), (1430, 1), (1440, 1), (1450, 1), (1460, 1), (1470, 1), (1480, 1), (1490, 1), (1500, 1), (1510, 1), (1520, 1), (1530, 1), (1540, 1), (1550, 1), (1560, 1), (1570, 1), (1580, 1), (1590, 1), (1600, 1), (1610, 1), (1620, 1), (1630, 1), (1640, 1), (1650, 1), (1660, 1), (1670, 0), (1680, 0), (1690, 0), (1700, 0), (1710, 0), (1720, 0), (1730, 0), (1740, 0), (1750, 1), (1760, 1), (1770, 1), (1780, 1), (1790, 0), (1800, 0), (1810, 0), (1820, 0), (1830, 0), (1840, 0), (1850, 1), (1860, 1), (1870, 1), (1880, 1), (1890, 1), (1900, 1), (1910, 1), (1920, 1), (1930, 1), (1940, 1), (1950, 1), (1960, 1), (1970, 0), (1980, 0), (1990, 0), (2000, 0), (2010, 0), (2020, 0), (2030, 0), (2040, 0), (2050, 0)]
Vdin0_7  din0_7  0 PWL (0n 0.0v 9.45n 0.0v 9.55n 0.0v 19.45n 0.0v 19.55n 0.0v 29.45n 0.0v 29.55n 5.0v 39.45n 5.0v 39.55n 5.0v 49.45n 5.0v 49.55n 5.0v 59.45n 5.0v 59.55n 5.0v 69.45n 5.0v 69.55n 5.0v 79.45n 5.0v 79.55n 5.0v 89.45n 5.0v 89.55n 5.0v 99.45n 5.0v 99.55n 5.0v 109.45n 5.0v 109.55n 5.0v 119.45n 5.0v 119.55n 0.0v 129.45n 0.0v 129.55n 5.0v 139.45n 5.0v 139.55n 5.0v 149.45n 5.0v 149.55n 5.0v 159.45n 5.0v 159.55n 5.0v 169.45n 5.0v 169.55n 0.0v 179.45n 0.0v 179.55n 5.0v 189.45n 5.0v 189.55n 5.0v 199.45n 5.0v 199.55n 5.0v 209.45n 5.0v 209.55n 5.0v 219.45n 5.0v 219.55n 5.0v 229.45n 5.0v 229.55n 5.0v 239.45n 5.0v 239.55n 5.0v 249.45n 5.0v 249.55n 5.0v 259.45n 5.0v 259.55n 5.0v 269.45n 5.0v 269.55n 5.0v 279.45n 5.0v 279.55n 5.0v 289.45n 5.0v 289.55n 0.0v 299.45n 0.0v 299.55n 5.0v 309.45n 5.0v 309.55n 5.0v 319.45n 5.0v 319.55n 5.0v 329.45n 5.0v 329.55n 5.0v 339.45n 5.0v 339.55n 5.0v 349.45n 5.0v 349.55n 0.0v 359.45n 0.0v 359.55n 5.0v 369.45n 5.0v 369.55n 5.0v 379.45n 5.0v 379.55n 5.0v 389.45n 5.0v 389.55n 5.0v 399.45n 5.0v 399.55n 5.0v 409.45n 5.0v 409.55n 5.0v 419.45n 5.0v 419.55n 0.0v 429.45n 0.0v 429.55n 0.0v 439.45n 0.0v 439.55n 0.0v 449.45n 0.0v 449.55n 0.0v 459.45n 0.0v 459.55n 0.0v 469.45n 0.0v 469.55n 0.0v 479.45n 0.0v 479.55n 0.0v 489.45n 0.0v 489.55n 0.0v 499.45n 0.0v 499.55n 5.0v 509.45n 5.0v 509.55n 5.0v 519.45n 5.0v 519.55n 5.0v 529.45n 5.0v 529.55n 5.0v 539.45n 5.0v 539.55n 5.0v 549.45n 5.0v 549.55n 5.0v 559.45n 5.0v 559.55n 5.0v 569.45n 5.0v 569.55n 5.0v 579.45n 5.0v 579.55n 5.0v 589.45n 5.0v 589.55n 5.0v 599.45n 5.0v 599.55n 5.0v 609.45n 5.0v 609.55n 5.0v 619.45n 5.0v 619.55n 5.0v 629.45n 5.0v 629.55n 5.0v 639.45n 5.0v 639.55n 5.0v 649.45n 5.0v 649.55n 0.0v 659.45n 0.0v 659.55n 0.0v 669.45n 0.0v 669.55n 0.0v 679.45n 0.0v 679.55n 0.0v 689.45n 0.0v 689.55n 0.0v 699.45n 0.0v 699.55n 5.0v 709.45n 5.0v 709.55n 5.0v 719.45n 5.0v 719.55n 5.0v 729.45n 5.0v 729.55n 5.0v 739.45n 5.0v 739.55n 5.0v 749.45n 5.0v 749.55n 0.0v 759.45n 0.0v 759.55n 0.0v 769.45n 0.0v 769.55n 0.0v 779.45n 0.0v 779.55n 0.0v 789.45n 0.0v 789.55n 0.0v 799.45n 0.0v 799.55n 0.0v 809.45n 0.0v 809.55n 0.0v 819.45n 0.0v 819.55n 0.0v 829.45n 0.0v 829.55n 0.0v 839.45n 0.0v 839.55n 0.0v 849.45n 0.0v 849.55n 0.0v 859.45n 0.0v 859.55n 0.0v 869.45n 0.0v 869.55n 0.0v 879.45n 0.0v 879.55n 5.0v 889.45n 5.0v 889.55n 5.0v 899.45n 5.0v 899.55n 5.0v 909.45n 5.0v 909.55n 5.0v 919.45n 5.0v 919.55n 5.0v 929.45n 5.0v 929.55n 5.0v 939.45n 5.0v 939.55n 5.0v 949.45n 5.0v 949.55n 0.0v 959.45n 0.0v 959.55n 0.0v 969.45n 0.0v 969.55n 0.0v 979.45n 0.0v 979.55n 0.0v 989.45n 0.0v 989.55n 5.0v 999.45n 5.0v 999.55n 5.0v 1009.45n 5.0v 1009.55n 5.0v 1019.45n 5.0v 1019.55n 5.0v 1029.45n 5.0v 1029.55n 5.0v 1039.45n 5.0v 1039.55n 0.0v 1049.45n 0.0v 1049.55n 0.0v 1059.45n 0.0v 1059.55n 0.0v 1069.45n 0.0v 1069.55n 5.0v 1079.45n 5.0v 1079.55n 5.0v 1089.45n 5.0v 1089.55n 5.0v 1099.45n 5.0v 1099.55n 5.0v 1109.45n 5.0v 1109.55n 5.0v 1119.45n 5.0v 1119.55n 5.0v 1129.45n 5.0v 1129.55n 5.0v 1139.45n 5.0v 1139.55n 5.0v 1149.45n 5.0v 1149.55n 5.0v 1159.45n 5.0v 1159.55n 5.0v 1169.45n 5.0v 1169.55n 5.0v 1179.45n 5.0v 1179.55n 0.0v 1189.45n 0.0v 1189.55n 0.0v 1199.45n 0.0v 1199.55n 0.0v 1209.45n 0.0v 1209.55n 5.0v 1219.45n 5.0v 1219.55n 0.0v 1229.45n 0.0v 1229.55n 0.0v 1239.45n 0.0v 1239.55n 5.0v 1249.45n 5.0v 1249.55n 5.0v 1259.45n 5.0v 1259.55n 5.0v 1269.45n 5.0v 1269.55n 5.0v 1279.45n 5.0v 1279.55n 0.0v 1289.45n 0.0v 1289.55n 0.0v 1299.45n 0.0v 1299.55n 0.0v 1309.45n 0.0v 1309.55n 0.0v 1319.45n 0.0v 1319.55n 5.0v 1329.45n 5.0v 1329.55n 5.0v 1339.45n 5.0v 1339.55n 5.0v 1349.45n 5.0v 1349.55n 5.0v 1359.45n 5.0v 1359.55n 5.0v 1369.45n 5.0v 1369.55n 5.0v 1379.45n 5.0v 1379.55n 5.0v 1389.45n 5.0v 1389.55n 5.0v 1399.45n 5.0v 1399.55n 5.0v 1409.45n 5.0v 1409.55n 5.0v 1419.45n 5.0v 1419.55n 5.0v 1429.45n 5.0v 1429.55n 5.0v 1439.45n 5.0v 1439.55n 5.0v 1449.45n 5.0v 1449.55n 5.0v 1459.45n 5.0v 1459.55n 5.0v 1469.45n 5.0v 1469.55n 5.0v 1479.45n 5.0v 1479.55n 5.0v 1489.45n 5.0v 1489.55n 5.0v 1499.45n 5.0v 1499.55n 5.0v 1509.45n 5.0v 1509.55n 5.0v 1519.45n 5.0v 1519.55n 5.0v 1529.45n 5.0v 1529.55n 5.0v 1539.45n 5.0v 1539.55n 5.0v 1549.45n 5.0v 1549.55n 5.0v 1559.45n 5.0v 1559.55n 5.0v 1569.45n 5.0v 1569.55n 5.0v 1579.45n 5.0v 1579.55n 5.0v 1589.45n 5.0v 1589.55n 5.0v 1599.45n 5.0v 1599.55n 5.0v 1609.45n 5.0v 1609.55n 5.0v 1619.45n 5.0v 1619.55n 5.0v 1629.45n 5.0v 1629.55n 5.0v 1639.45n 5.0v 1639.55n 5.0v 1649.45n 5.0v 1649.55n 5.0v 1659.45n 5.0v 1659.55n 5.0v 1669.45n 5.0v 1669.55n 0.0v 1679.45n 0.0v 1679.55n 0.0v 1689.45n 0.0v 1689.55n 0.0v 1699.45n 0.0v 1699.55n 0.0v 1709.45n 0.0v 1709.55n 0.0v 1719.45n 0.0v 1719.55n 0.0v 1729.45n 0.0v 1729.55n 0.0v 1739.45n 0.0v 1739.55n 0.0v 1749.45n 0.0v 1749.55n 5.0v 1759.45n 5.0v 1759.55n 5.0v 1769.45n 5.0v 1769.55n 5.0v 1779.45n 5.0v 1779.55n 5.0v 1789.45n 5.0v 1789.55n 0.0v 1799.45n 0.0v 1799.55n 0.0v 1809.45n 0.0v 1809.55n 0.0v 1819.45n 0.0v 1819.55n 0.0v 1829.45n 0.0v 1829.55n 0.0v 1839.45n 0.0v 1839.55n 0.0v 1849.45n 0.0v 1849.55n 5.0v 1859.45n 5.0v 1859.55n 5.0v 1869.45n 5.0v 1869.55n 5.0v 1879.45n 5.0v 1879.55n 5.0v 1889.45n 5.0v 1889.55n 5.0v 1899.45n 5.0v 1899.55n 5.0v 1909.45n 5.0v 1909.55n 5.0v 1919.45n 5.0v 1919.55n 5.0v 1929.45n 5.0v 1929.55n 5.0v 1939.45n 5.0v 1939.55n 5.0v 1949.45n 5.0v 1949.55n 5.0v 1959.45n 5.0v 1959.55n 5.0v 1969.45n 5.0v 1969.55n 0.0v 1979.45n 0.0v 1979.55n 0.0v 1989.45n 0.0v 1989.55n 0.0v 1999.45n 0.0v 1999.55n 0.0v 2009.45n 0.0v 2009.55n 0.0v 2019.45n 0.0v 2019.55n 0.0v 2029.45n 0.0v 2029.55n 0.0v 2039.45n 0.0v 2039.55n 0.0v 2049.45n 0.0v 2049.55n 0.0v )
* (time, data): [(0, 0), (10, 0), (20, 1), (30, 1), (40, 1), (50, 1), (60, 1), (70, 1), (80, 1), (90, 1), (100, 1), (110, 1), (120, 0), (130, 1), (140, 1), (150, 1), (160, 1), (170, 0), (180, 0), (190, 0), (200, 0), (210, 0), (220, 0), (230, 0), (240, 0), (250, 0), (260, 0), (270, 0), (280, 0), (290, 0), (300, 0), (310, 0), (320, 0), (330, 0), (340, 0), (350, 0), (360, 0), (370, 0), (380, 0), (390, 0), (400, 0), (410, 0), (420, 0), (430, 0), (440, 0), (450, 0), (460, 0), (470, 0), (480, 0), (490, 0), (500, 1), (510, 1), (520, 1), (530, 1), (540, 1), (550, 1), (560, 1), (570, 1), (580, 1), (590, 1), (600, 1), (610, 1), (620, 1), (630, 1), (640, 1), (650, 1), (660, 1), (670, 1), (680, 1), (690, 1), (700, 1), (710, 1), (720, 1), (730, 1), (740, 1), (750, 1), (760, 1), (770, 1), (780, 1), (790, 1), (800, 1), (810, 1), (820, 1), (830, 1), (840, 1), (850, 1), (860, 1), (870, 1), (880, 1), (890, 1), (900, 1), (910, 1), (920, 1), (930, 1), (940, 1), (950, 1), (960, 1), (970, 1), (980, 1), (990, 0), (1000, 0), (1010, 0), (1020, 0), (1030, 0), (1040, 0), (1050, 0), (1060, 0), (1070, 0), (1080, 0), (1090, 0), (1100, 0), (1110, 0), (1120, 0), (1130, 0), (1140, 0), (1150, 0), (1160, 0), (1170, 0), (1180, 1), (1190, 1), (1200, 1), (1210, 0), (1220, 0), (1230, 0), (1240, 0), (1250, 0), (1260, 0), (1270, 0), (1280, 1), (1290, 1), (1300, 1), (1310, 1), (1320, 0), (1330, 0), (1340, 0), (1350, 0), (1360, 1), (1370, 1), (1380, 1), (1390, 1), (1400, 1), (1410, 1), (1420, 1), (1430, 1), (1440, 1), (1450, 1), (1460, 1), (1470, 1), (1480, 1), (1490, 1), (1500, 1), (1510, 1), (1520, 1), (1530, 1), (1540, 1), (1550, 1), (1560, 1), (1570, 1), (1580, 1), (1590, 1), (1600, 1), (1610, 1), (1620, 1), (1630, 1), (1640, 1), (1650, 1), (1660, 1), (1670, 0), (1680, 0), (1690, 0), (1700, 0), (1710, 0), (1720, 1), (1730, 0), (1740, 0), (1750, 0), (1760, 0), (1770, 0), (1780, 0), (1790, 0), (1800, 0), (1810, 0), (1820, 0), (1830, 0), (1840, 0), (1850, 1), (1860, 1), (1870, 1), (1880, 1), (1890, 1), (1900, 1), (1910, 1), (1920, 1), (1930, 1), (1940, 1), (1950, 1), (1960, 1), (1970, 0), (1980, 0), (1990, 0), (2000, 0), (2010, 0), (2020, 0), (2030, 0), (2040, 0), (2050, 0)]
Vdin0_8  din0_8  0 PWL (0n 0.0v 9.45n 0.0v 9.55n 0.0v 19.45n 0.0v 19.55n 5.0v 29.45n 5.0v 29.55n 5.0v 39.45n 5.0v 39.55n 5.0v 49.45n 5.0v 49.55n 5.0v 59.45n 5.0v 59.55n 5.0v 69.45n 5.0v 69.55n 5.0v 79.45n 5.0v 79.55n 5.0v 89.45n 5.0v 89.55n 5.0v 99.45n 5.0v 99.55n 5.0v 109.45n 5.0v 109.55n 5.0v 119.45n 5.0v 119.55n 0.0v 129.45n 0.0v 129.55n 5.0v 139.45n 5.0v 139.55n 5.0v 149.45n 5.0v 149.55n 5.0v 159.45n 5.0v 159.55n 5.0v 169.45n 5.0v 169.55n 0.0v 179.45n 0.0v 179.55n 0.0v 189.45n 0.0v 189.55n 0.0v 199.45n 0.0v 199.55n 0.0v 209.45n 0.0v 209.55n 0.0v 219.45n 0.0v 219.55n 0.0v 229.45n 0.0v 229.55n 0.0v 239.45n 0.0v 239.55n 0.0v 249.45n 0.0v 249.55n 0.0v 259.45n 0.0v 259.55n 0.0v 269.45n 0.0v 269.55n 0.0v 279.45n 0.0v 279.55n 0.0v 289.45n 0.0v 289.55n 0.0v 299.45n 0.0v 299.55n 0.0v 309.45n 0.0v 309.55n 0.0v 319.45n 0.0v 319.55n 0.0v 329.45n 0.0v 329.55n 0.0v 339.45n 0.0v 339.55n 0.0v 349.45n 0.0v 349.55n 0.0v 359.45n 0.0v 359.55n 0.0v 369.45n 0.0v 369.55n 0.0v 379.45n 0.0v 379.55n 0.0v 389.45n 0.0v 389.55n 0.0v 399.45n 0.0v 399.55n 0.0v 409.45n 0.0v 409.55n 0.0v 419.45n 0.0v 419.55n 0.0v 429.45n 0.0v 429.55n 0.0v 439.45n 0.0v 439.55n 0.0v 449.45n 0.0v 449.55n 0.0v 459.45n 0.0v 459.55n 0.0v 469.45n 0.0v 469.55n 0.0v 479.45n 0.0v 479.55n 0.0v 489.45n 0.0v 489.55n 0.0v 499.45n 0.0v 499.55n 5.0v 509.45n 5.0v 509.55n 5.0v 519.45n 5.0v 519.55n 5.0v 529.45n 5.0v 529.55n 5.0v 539.45n 5.0v 539.55n 5.0v 549.45n 5.0v 549.55n 5.0v 559.45n 5.0v 559.55n 5.0v 569.45n 5.0v 569.55n 5.0v 579.45n 5.0v 579.55n 5.0v 589.45n 5.0v 589.55n 5.0v 599.45n 5.0v 599.55n 5.0v 609.45n 5.0v 609.55n 5.0v 619.45n 5.0v 619.55n 5.0v 629.45n 5.0v 629.55n 5.0v 639.45n 5.0v 639.55n 5.0v 649.45n 5.0v 649.55n 5.0v 659.45n 5.0v 659.55n 5.0v 669.45n 5.0v 669.55n 5.0v 679.45n 5.0v 679.55n 5.0v 689.45n 5.0v 689.55n 5.0v 699.45n 5.0v 699.55n 5.0v 709.45n 5.0v 709.55n 5.0v 719.45n 5.0v 719.55n 5.0v 729.45n 5.0v 729.55n 5.0v 739.45n 5.0v 739.55n 5.0v 749.45n 5.0v 749.55n 5.0v 759.45n 5.0v 759.55n 5.0v 769.45n 5.0v 769.55n 5.0v 779.45n 5.0v 779.55n 5.0v 789.45n 5.0v 789.55n 5.0v 799.45n 5.0v 799.55n 5.0v 809.45n 5.0v 809.55n 5.0v 819.45n 5.0v 819.55n 5.0v 829.45n 5.0v 829.55n 5.0v 839.45n 5.0v 839.55n 5.0v 849.45n 5.0v 849.55n 5.0v 859.45n 5.0v 859.55n 5.0v 869.45n 5.0v 869.55n 5.0v 879.45n 5.0v 879.55n 5.0v 889.45n 5.0v 889.55n 5.0v 899.45n 5.0v 899.55n 5.0v 909.45n 5.0v 909.55n 5.0v 919.45n 5.0v 919.55n 5.0v 929.45n 5.0v 929.55n 5.0v 939.45n 5.0v 939.55n 5.0v 949.45n 5.0v 949.55n 5.0v 959.45n 5.0v 959.55n 5.0v 969.45n 5.0v 969.55n 5.0v 979.45n 5.0v 979.55n 5.0v 989.45n 5.0v 989.55n 0.0v 999.45n 0.0v 999.55n 0.0v 1009.45n 0.0v 1009.55n 0.0v 1019.45n 0.0v 1019.55n 0.0v 1029.45n 0.0v 1029.55n 0.0v 1039.45n 0.0v 1039.55n 0.0v 1049.45n 0.0v 1049.55n 0.0v 1059.45n 0.0v 1059.55n 0.0v 1069.45n 0.0v 1069.55n 0.0v 1079.45n 0.0v 1079.55n 0.0v 1089.45n 0.0v 1089.55n 0.0v 1099.45n 0.0v 1099.55n 0.0v 1109.45n 0.0v 1109.55n 0.0v 1119.45n 0.0v 1119.55n 0.0v 1129.45n 0.0v 1129.55n 0.0v 1139.45n 0.0v 1139.55n 0.0v 1149.45n 0.0v 1149.55n 0.0v 1159.45n 0.0v 1159.55n 0.0v 1169.45n 0.0v 1169.55n 0.0v 1179.45n 0.0v 1179.55n 5.0v 1189.45n 5.0v 1189.55n 5.0v 1199.45n 5.0v 1199.55n 5.0v 1209.45n 5.0v 1209.55n 0.0v 1219.45n 0.0v 1219.55n 0.0v 1229.45n 0.0v 1229.55n 0.0v 1239.45n 0.0v 1239.55n 0.0v 1249.45n 0.0v 1249.55n 0.0v 1259.45n 0.0v 1259.55n 0.0v 1269.45n 0.0v 1269.55n 0.0v 1279.45n 0.0v 1279.55n 5.0v 1289.45n 5.0v 1289.55n 5.0v 1299.45n 5.0v 1299.55n 5.0v 1309.45n 5.0v 1309.55n 5.0v 1319.45n 5.0v 1319.55n 0.0v 1329.45n 0.0v 1329.55n 0.0v 1339.45n 0.0v 1339.55n 0.0v 1349.45n 0.0v 1349.55n 0.0v 1359.45n 0.0v 1359.55n 5.0v 1369.45n 5.0v 1369.55n 5.0v 1379.45n 5.0v 1379.55n 5.0v 1389.45n 5.0v 1389.55n 5.0v 1399.45n 5.0v 1399.55n 5.0v 1409.45n 5.0v 1409.55n 5.0v 1419.45n 5.0v 1419.55n 5.0v 1429.45n 5.0v 1429.55n 5.0v 1439.45n 5.0v 1439.55n 5.0v 1449.45n 5.0v 1449.55n 5.0v 1459.45n 5.0v 1459.55n 5.0v 1469.45n 5.0v 1469.55n 5.0v 1479.45n 5.0v 1479.55n 5.0v 1489.45n 5.0v 1489.55n 5.0v 1499.45n 5.0v 1499.55n 5.0v 1509.45n 5.0v 1509.55n 5.0v 1519.45n 5.0v 1519.55n 5.0v 1529.45n 5.0v 1529.55n 5.0v 1539.45n 5.0v 1539.55n 5.0v 1549.45n 5.0v 1549.55n 5.0v 1559.45n 5.0v 1559.55n 5.0v 1569.45n 5.0v 1569.55n 5.0v 1579.45n 5.0v 1579.55n 5.0v 1589.45n 5.0v 1589.55n 5.0v 1599.45n 5.0v 1599.55n 5.0v 1609.45n 5.0v 1609.55n 5.0v 1619.45n 5.0v 1619.55n 5.0v 1629.45n 5.0v 1629.55n 5.0v 1639.45n 5.0v 1639.55n 5.0v 1649.45n 5.0v 1649.55n 5.0v 1659.45n 5.0v 1659.55n 5.0v 1669.45n 5.0v 1669.55n 0.0v 1679.45n 0.0v 1679.55n 0.0v 1689.45n 0.0v 1689.55n 0.0v 1699.45n 0.0v 1699.55n 0.0v 1709.45n 0.0v 1709.55n 0.0v 1719.45n 0.0v 1719.55n 5.0v 1729.45n 5.0v 1729.55n 0.0v 1739.45n 0.0v 1739.55n 0.0v 1749.45n 0.0v 1749.55n 0.0v 1759.45n 0.0v 1759.55n 0.0v 1769.45n 0.0v 1769.55n 0.0v 1779.45n 0.0v 1779.55n 0.0v 1789.45n 0.0v 1789.55n 0.0v 1799.45n 0.0v 1799.55n 0.0v 1809.45n 0.0v 1809.55n 0.0v 1819.45n 0.0v 1819.55n 0.0v 1829.45n 0.0v 1829.55n 0.0v 1839.45n 0.0v 1839.55n 0.0v 1849.45n 0.0v 1849.55n 5.0v 1859.45n 5.0v 1859.55n 5.0v 1869.45n 5.0v 1869.55n 5.0v 1879.45n 5.0v 1879.55n 5.0v 1889.45n 5.0v 1889.55n 5.0v 1899.45n 5.0v 1899.55n 5.0v 1909.45n 5.0v 1909.55n 5.0v 1919.45n 5.0v 1919.55n 5.0v 1929.45n 5.0v 1929.55n 5.0v 1939.45n 5.0v 1939.55n 5.0v 1949.45n 5.0v 1949.55n 5.0v 1959.45n 5.0v 1959.55n 5.0v 1969.45n 5.0v 1969.55n 0.0v 1979.45n 0.0v 1979.55n 0.0v 1989.45n 0.0v 1989.55n 0.0v 1999.45n 0.0v 1999.55n 0.0v 2009.45n 0.0v 2009.55n 0.0v 2019.45n 0.0v 2019.55n 0.0v 2029.45n 0.0v 2029.55n 0.0v 2039.45n 0.0v 2039.55n 0.0v 2049.45n 0.0v 2049.55n 0.0v )
* (time, data): [(0, 0), (10, 0), (20, 1), (30, 0), (40, 0), (50, 0), (60, 0), (70, 0), (80, 0), (90, 0), (100, 0), (110, 0), (120, 1), (130, 0), (140, 0), (150, 0), (160, 0), (170, 0), (180, 0), (190, 0), (200, 0), (210, 0), (220, 0), (230, 0), (240, 0), (250, 0), (260, 0), (270, 0), (280, 0), (290, 0), (300, 0), (310, 0), (320, 0), (330, 0), (340, 0), (350, 0), (360, 1), (370, 1), (380, 1), (390, 1), (400, 1), (410, 1), (420, 0), (430, 0), (440, 0), (450, 1), (460, 1), (470, 1), (480, 1), (490, 1), (500, 1), (510, 1), (520, 1), (530, 1), (540, 1), (550, 1), (560, 1), (570, 1), (580, 1), (590, 1), (600, 1), (610, 1), (620, 1), (630, 1), (640, 0), (650, 1), (660, 1), (670, 1), (680, 1), (690, 1), (700, 1), (710, 1), (720, 1), (730, 1), (740, 1), (750, 0), (760, 0), (770, 0), (780, 0), (790, 0), (800, 0), (810, 0), (820, 0), (830, 0), (840, 1), (850, 1), (860, 1), (870, 1), (880, 1), (890, 1), (900, 1), (910, 1), (920, 1), (930, 1), (940, 1), (950, 0), (960, 0), (970, 0), (980, 0), (990, 0), (1000, 0), (1010, 0), (1020, 0), (1030, 0), (1040, 1), (1050, 1), (1060, 1), (1070, 0), (1080, 0), (1090, 0), (1100, 0), (1110, 0), (1120, 0), (1130, 0), (1140, 0), (1150, 0), (1160, 0), (1170, 0), (1180, 0), (1190, 0), (1200, 0), (1210, 0), (1220, 0), (1230, 0), (1240, 1), (1250, 1), (1260, 1), (1270, 1), (1280, 1), (1290, 0), (1300, 0), (1310, 0), (1320, 1), (1330, 1), (1340, 1), (1350, 1), (1360, 0), (1370, 0), (1380, 0), (1390, 0), (1400, 0), (1410, 0), (1420, 0), (1430, 0), (1440, 0), (1450, 0), (1460, 0), (1470, 0), (1480, 0), (1490, 0), (1500, 0), (1510, 0), (1520, 0), (1530, 0), (1540, 0), (1550, 0), (1560, 0), (1570, 0), (1580, 0), (1590, 0), (1600, 0), (1610, 0), (1620, 0), (1630, 0), (1640, 0), (1650, 0), (1660, 0), (1670, 0), (1680, 0), (1690, 0), (1700, 0), (1710, 0), (1720, 1), (1730, 1), (1740, 0), (1750, 0), (1760, 0), (1770, 0), (1780, 0), (1790, 0), (1800, 0), (1810, 1), (1820, 1), (1830, 1), (1840, 1), (1850, 1), (1860, 1), (1870, 1), (1880, 1), (1890, 1), (1900, 1), (1910, 1), (1920, 1), (1930, 1), (1940, 1), (1950, 1), (1960, 1), (1970, 0), (1980, 0), (1990, 0), (2000, 0), (2010, 0), (2020, 0), (2030, 0), (2040, 0), (2050, 0)]
Vdin0_9  din0_9  0 PWL (0n 0.0v 9.45n 0.0v 9.55n 0.0v 19.45n 0.0v 19.55n 5.0v 29.45n 5.0v 29.55n 0.0v 39.45n 0.0v 39.55n 0.0v 49.45n 0.0v 49.55n 0.0v 59.45n 0.0v 59.55n 0.0v 69.45n 0.0v 69.55n 0.0v 79.45n 0.0v 79.55n 0.0v 89.45n 0.0v 89.55n 0.0v 99.45n 0.0v 99.55n 0.0v 109.45n 0.0v 109.55n 0.0v 119.45n 0.0v 119.55n 5.0v 129.45n 5.0v 129.55n 0.0v 139.45n 0.0v 139.55n 0.0v 149.45n 0.0v 149.55n 0.0v 159.45n 0.0v 159.55n 0.0v 169.45n 0.0v 169.55n 0.0v 179.45n 0.0v 179.55n 0.0v 189.45n 0.0v 189.55n 0.0v 199.45n 0.0v 199.55n 0.0v 209.45n 0.0v 209.55n 0.0v 219.45n 0.0v 219.55n 0.0v 229.45n 0.0v 229.55n 0.0v 239.45n 0.0v 239.55n 0.0v 249.45n 0.0v 249.55n 0.0v 259.45n 0.0v 259.55n 0.0v 269.45n 0.0v 269.55n 0.0v 279.45n 0.0v 279.55n 0.0v 289.45n 0.0v 289.55n 0.0v 299.45n 0.0v 299.55n 0.0v 309.45n 0.0v 309.55n 0.0v 319.45n 0.0v 319.55n 0.0v 329.45n 0.0v 329.55n 0.0v 339.45n 0.0v 339.55n 0.0v 349.45n 0.0v 349.55n 0.0v 359.45n 0.0v 359.55n 5.0v 369.45n 5.0v 369.55n 5.0v 379.45n 5.0v 379.55n 5.0v 389.45n 5.0v 389.55n 5.0v 399.45n 5.0v 399.55n 5.0v 409.45n 5.0v 409.55n 5.0v 419.45n 5.0v 419.55n 0.0v 429.45n 0.0v 429.55n 0.0v 439.45n 0.0v 439.55n 0.0v 449.45n 0.0v 449.55n 5.0v 459.45n 5.0v 459.55n 5.0v 469.45n 5.0v 469.55n 5.0v 479.45n 5.0v 479.55n 5.0v 489.45n 5.0v 489.55n 5.0v 499.45n 5.0v 499.55n 5.0v 509.45n 5.0v 509.55n 5.0v 519.45n 5.0v 519.55n 5.0v 529.45n 5.0v 529.55n 5.0v 539.45n 5.0v 539.55n 5.0v 549.45n 5.0v 549.55n 5.0v 559.45n 5.0v 559.55n 5.0v 569.45n 5.0v 569.55n 5.0v 579.45n 5.0v 579.55n 5.0v 589.45n 5.0v 589.55n 5.0v 599.45n 5.0v 599.55n 5.0v 609.45n 5.0v 609.55n 5.0v 619.45n 5.0v 619.55n 5.0v 629.45n 5.0v 629.55n 5.0v 639.45n 5.0v 639.55n 0.0v 649.45n 0.0v 649.55n 5.0v 659.45n 5.0v 659.55n 5.0v 669.45n 5.0v 669.55n 5.0v 679.45n 5.0v 679.55n 5.0v 689.45n 5.0v 689.55n 5.0v 699.45n 5.0v 699.55n 5.0v 709.45n 5.0v 709.55n 5.0v 719.45n 5.0v 719.55n 5.0v 729.45n 5.0v 729.55n 5.0v 739.45n 5.0v 739.55n 5.0v 749.45n 5.0v 749.55n 0.0v 759.45n 0.0v 759.55n 0.0v 769.45n 0.0v 769.55n 0.0v 779.45n 0.0v 779.55n 0.0v 789.45n 0.0v 789.55n 0.0v 799.45n 0.0v 799.55n 0.0v 809.45n 0.0v 809.55n 0.0v 819.45n 0.0v 819.55n 0.0v 829.45n 0.0v 829.55n 0.0v 839.45n 0.0v 839.55n 5.0v 849.45n 5.0v 849.55n 5.0v 859.45n 5.0v 859.55n 5.0v 869.45n 5.0v 869.55n 5.0v 879.45n 5.0v 879.55n 5.0v 889.45n 5.0v 889.55n 5.0v 899.45n 5.0v 899.55n 5.0v 909.45n 5.0v 909.55n 5.0v 919.45n 5.0v 919.55n 5.0v 929.45n 5.0v 929.55n 5.0v 939.45n 5.0v 939.55n 5.0v 949.45n 5.0v 949.55n 0.0v 959.45n 0.0v 959.55n 0.0v 969.45n 0.0v 969.55n 0.0v 979.45n 0.0v 979.55n 0.0v 989.45n 0.0v 989.55n 0.0v 999.45n 0.0v 999.55n 0.0v 1009.45n 0.0v 1009.55n 0.0v 1019.45n 0.0v 1019.55n 0.0v 1029.45n 0.0v 1029.55n 0.0v 1039.45n 0.0v 1039.55n 5.0v 1049.45n 5.0v 1049.55n 5.0v 1059.45n 5.0v 1059.55n 5.0v 1069.45n 5.0v 1069.55n 0.0v 1079.45n 0.0v 1079.55n 0.0v 1089.45n 0.0v 1089.55n 0.0v 1099.45n 0.0v 1099.55n 0.0v 1109.45n 0.0v 1109.55n 0.0v 1119.45n 0.0v 1119.55n 0.0v 1129.45n 0.0v 1129.55n 0.0v 1139.45n 0.0v 1139.55n 0.0v 1149.45n 0.0v 1149.55n 0.0v 1159.45n 0.0v 1159.55n 0.0v 1169.45n 0.0v 1169.55n 0.0v 1179.45n 0.0v 1179.55n 0.0v 1189.45n 0.0v 1189.55n 0.0v 1199.45n 0.0v 1199.55n 0.0v 1209.45n 0.0v 1209.55n 0.0v 1219.45n 0.0v 1219.55n 0.0v 1229.45n 0.0v 1229.55n 0.0v 1239.45n 0.0v 1239.55n 5.0v 1249.45n 5.0v 1249.55n 5.0v 1259.45n 5.0v 1259.55n 5.0v 1269.45n 5.0v 1269.55n 5.0v 1279.45n 5.0v 1279.55n 5.0v 1289.45n 5.0v 1289.55n 0.0v 1299.45n 0.0v 1299.55n 0.0v 1309.45n 0.0v 1309.55n 0.0v 1319.45n 0.0v 1319.55n 5.0v 1329.45n 5.0v 1329.55n 5.0v 1339.45n 5.0v 1339.55n 5.0v 1349.45n 5.0v 1349.55n 5.0v 1359.45n 5.0v 1359.55n 0.0v 1369.45n 0.0v 1369.55n 0.0v 1379.45n 0.0v 1379.55n 0.0v 1389.45n 0.0v 1389.55n 0.0v 1399.45n 0.0v 1399.55n 0.0v 1409.45n 0.0v 1409.55n 0.0v 1419.45n 0.0v 1419.55n 0.0v 1429.45n 0.0v 1429.55n 0.0v 1439.45n 0.0v 1439.55n 0.0v 1449.45n 0.0v 1449.55n 0.0v 1459.45n 0.0v 1459.55n 0.0v 1469.45n 0.0v 1469.55n 0.0v 1479.45n 0.0v 1479.55n 0.0v 1489.45n 0.0v 1489.55n 0.0v 1499.45n 0.0v 1499.55n 0.0v 1509.45n 0.0v 1509.55n 0.0v 1519.45n 0.0v 1519.55n 0.0v 1529.45n 0.0v 1529.55n 0.0v 1539.45n 0.0v 1539.55n 0.0v 1549.45n 0.0v 1549.55n 0.0v 1559.45n 0.0v 1559.55n 0.0v 1569.45n 0.0v 1569.55n 0.0v 1579.45n 0.0v 1579.55n 0.0v 1589.45n 0.0v 1589.55n 0.0v 1599.45n 0.0v 1599.55n 0.0v 1609.45n 0.0v 1609.55n 0.0v 1619.45n 0.0v 1619.55n 0.0v 1629.45n 0.0v 1629.55n 0.0v 1639.45n 0.0v 1639.55n 0.0v 1649.45n 0.0v 1649.55n 0.0v 1659.45n 0.0v 1659.55n 0.0v 1669.45n 0.0v 1669.55n 0.0v 1679.45n 0.0v 1679.55n 0.0v 1689.45n 0.0v 1689.55n 0.0v 1699.45n 0.0v 1699.55n 0.0v 1709.45n 0.0v 1709.55n 0.0v 1719.45n 0.0v 1719.55n 5.0v 1729.45n 5.0v 1729.55n 5.0v 1739.45n 5.0v 1739.55n 0.0v 1749.45n 0.0v 1749.55n 0.0v 1759.45n 0.0v 1759.55n 0.0v 1769.45n 0.0v 1769.55n 0.0v 1779.45n 0.0v 1779.55n 0.0v 1789.45n 0.0v 1789.55n 0.0v 1799.45n 0.0v 1799.55n 0.0v 1809.45n 0.0v 1809.55n 5.0v 1819.45n 5.0v 1819.55n 5.0v 1829.45n 5.0v 1829.55n 5.0v 1839.45n 5.0v 1839.55n 5.0v 1849.45n 5.0v 1849.55n 5.0v 1859.45n 5.0v 1859.55n 5.0v 1869.45n 5.0v 1869.55n 5.0v 1879.45n 5.0v 1879.55n 5.0v 1889.45n 5.0v 1889.55n 5.0v 1899.45n 5.0v 1899.55n 5.0v 1909.45n 5.0v 1909.55n 5.0v 1919.45n 5.0v 1919.55n 5.0v 1929.45n 5.0v 1929.55n 5.0v 1939.45n 5.0v 1939.55n 5.0v 1949.45n 5.0v 1949.55n 5.0v 1959.45n 5.0v 1959.55n 5.0v 1969.45n 5.0v 1969.55n 0.0v 1979.45n 0.0v 1979.55n 0.0v 1989.45n 0.0v 1989.55n 0.0v 1999.45n 0.0v 1999.55n 0.0v 2009.45n 0.0v 2009.55n 0.0v 2019.45n 0.0v 2019.55n 0.0v 2029.45n 0.0v 2029.55n 0.0v 2039.45n 0.0v 2039.55n 0.0v 2049.45n 0.0v 2049.55n 0.0v )
* (time, data): [(0, 0), (10, 1), (20, 1), (30, 0), (40, 0), (50, 0), (60, 0), (70, 0), (80, 0), (90, 0), (100, 0), (110, 0), (120, 0), (130, 0), (140, 0), (150, 0), (160, 0), (170, 0), (180, 1), (190, 1), (200, 1), (210, 1), (220, 1), (230, 1), (240, 1), (250, 1), (260, 1), (270, 1), (280, 1), (290, 0), (300, 1), (310, 1), (320, 1), (330, 1), (340, 1), (350, 0), (360, 0), (370, 0), (380, 0), (390, 0), (400, 0), (410, 0), (420, 0), (430, 0), (440, 0), (450, 1), (460, 1), (470, 1), (480, 1), (490, 1), (500, 1), (510, 1), (520, 1), (530, 1), (540, 1), (550, 1), (560, 1), (570, 1), (580, 1), (590, 1), (600, 1), (610, 1), (620, 1), (630, 1), (640, 0), (650, 0), (660, 0), (670, 0), (680, 0), (690, 0), (700, 0), (710, 0), (720, 0), (730, 0), (740, 0), (750, 0), (760, 0), (770, 0), (780, 0), (790, 0), (800, 0), (810, 0), (820, 0), (830, 0), (840, 0), (850, 0), (860, 0), (870, 0), (880, 1), (890, 1), (900, 1), (910, 1), (920, 1), (930, 1), (940, 1), (950, 0), (960, 0), (970, 0), (980, 0), (990, 1), (1000, 1), (1010, 1), (1020, 1), (1030, 0), (1040, 1), (1050, 1), (1060, 1), (1070, 1), (1080, 1), (1090, 1), (1100, 1), (1110, 1), (1120, 1), (1130, 1), (1140, 1), (1150, 1), (1160, 1), (1170, 1), (1180, 0), (1190, 0), (1200, 0), (1210, 0), (1220, 0), (1230, 0), (1240, 1), (1250, 1), (1260, 1), (1270, 1), (1280, 1), (1290, 1), (1300, 1), (1310, 1), (1320, 1), (1330, 1), (1340, 1), (1350, 1), (1360, 0), (1370, 0), (1380, 0), (1390, 0), (1400, 0), (1410, 0), (1420, 0), (1430, 0), (1440, 0), (1450, 0), (1460, 0), (1470, 0), (1480, 0), (1490, 0), (1500, 0), (1510, 0), (1520, 0), (1530, 0), (1540, 0), (1550, 0), (1560, 0), (1570, 0), (1580, 0), (1590, 0), (1600, 0), (1610, 0), (1620, 0), (1630, 0), (1640, 0), (1650, 0), (1660, 0), (1670, 1), (1680, 1), (1690, 1), (1700, 1), (1710, 1), (1720, 1), (1730, 1), (1740, 1), (1750, 1), (1760, 1), (1770, 1), (1780, 1), (1790, 1), (1800, 1), (1810, 1), (1820, 1), (1830, 1), (1840, 1), (1850, 1), (1860, 1), (1870, 1), (1880, 1), (1890, 1), (1900, 1), (1910, 1), (1920, 1), (1930, 1), (1940, 1), (1950, 1), (1960, 1), (1970, 0), (1980, 0), (1990, 0), (2000, 0), (2010, 0), (2020, 0), (2030, 0), (2040, 0), (2050, 0)]
Vdin0_10  din0_10  0 PWL (0n 0.0v 9.45n 0.0v 9.55n 5.0v 19.45n 5.0v 19.55n 5.0v 29.45n 5.0v 29.55n 0.0v 39.45n 0.0v 39.55n 0.0v 49.45n 0.0v 49.55n 0.0v 59.45n 0.0v 59.55n 0.0v 69.45n 0.0v 69.55n 0.0v 79.45n 0.0v 79.55n 0.0v 89.45n 0.0v 89.55n 0.0v 99.45n 0.0v 99.55n 0.0v 109.45n 0.0v 109.55n 0.0v 119.45n 0.0v 119.55n 0.0v 129.45n 0.0v 129.55n 0.0v 139.45n 0.0v 139.55n 0.0v 149.45n 0.0v 149.55n 0.0v 159.45n 0.0v 159.55n 0.0v 169.45n 0.0v 169.55n 0.0v 179.45n 0.0v 179.55n 5.0v 189.45n 5.0v 189.55n 5.0v 199.45n 5.0v 199.55n 5.0v 209.45n 5.0v 209.55n 5.0v 219.45n 5.0v 219.55n 5.0v 229.45n 5.0v 229.55n 5.0v 239.45n 5.0v 239.55n 5.0v 249.45n 5.0v 249.55n 5.0v 259.45n 5.0v 259.55n 5.0v 269.45n 5.0v 269.55n 5.0v 279.45n 5.0v 279.55n 5.0v 289.45n 5.0v 289.55n 0.0v 299.45n 0.0v 299.55n 5.0v 309.45n 5.0v 309.55n 5.0v 319.45n 5.0v 319.55n 5.0v 329.45n 5.0v 329.55n 5.0v 339.45n 5.0v 339.55n 5.0v 349.45n 5.0v 349.55n 0.0v 359.45n 0.0v 359.55n 0.0v 369.45n 0.0v 369.55n 0.0v 379.45n 0.0v 379.55n 0.0v 389.45n 0.0v 389.55n 0.0v 399.45n 0.0v 399.55n 0.0v 409.45n 0.0v 409.55n 0.0v 419.45n 0.0v 419.55n 0.0v 429.45n 0.0v 429.55n 0.0v 439.45n 0.0v 439.55n 0.0v 449.45n 0.0v 449.55n 5.0v 459.45n 5.0v 459.55n 5.0v 469.45n 5.0v 469.55n 5.0v 479.45n 5.0v 479.55n 5.0v 489.45n 5.0v 489.55n 5.0v 499.45n 5.0v 499.55n 5.0v 509.45n 5.0v 509.55n 5.0v 519.45n 5.0v 519.55n 5.0v 529.45n 5.0v 529.55n 5.0v 539.45n 5.0v 539.55n 5.0v 549.45n 5.0v 549.55n 5.0v 559.45n 5.0v 559.55n 5.0v 569.45n 5.0v 569.55n 5.0v 579.45n 5.0v 579.55n 5.0v 589.45n 5.0v 589.55n 5.0v 599.45n 5.0v 599.55n 5.0v 609.45n 5.0v 609.55n 5.0v 619.45n 5.0v 619.55n 5.0v 629.45n 5.0v 629.55n 5.0v 639.45n 5.0v 639.55n 0.0v 649.45n 0.0v 649.55n 0.0v 659.45n 0.0v 659.55n 0.0v 669.45n 0.0v 669.55n 0.0v 679.45n 0.0v 679.55n 0.0v 689.45n 0.0v 689.55n 0.0v 699.45n 0.0v 699.55n 0.0v 709.45n 0.0v 709.55n 0.0v 719.45n 0.0v 719.55n 0.0v 729.45n 0.0v 729.55n 0.0v 739.45n 0.0v 739.55n 0.0v 749.45n 0.0v 749.55n 0.0v 759.45n 0.0v 759.55n 0.0v 769.45n 0.0v 769.55n 0.0v 779.45n 0.0v 779.55n 0.0v 789.45n 0.0v 789.55n 0.0v 799.45n 0.0v 799.55n 0.0v 809.45n 0.0v 809.55n 0.0v 819.45n 0.0v 819.55n 0.0v 829.45n 0.0v 829.55n 0.0v 839.45n 0.0v 839.55n 0.0v 849.45n 0.0v 849.55n 0.0v 859.45n 0.0v 859.55n 0.0v 869.45n 0.0v 869.55n 0.0v 879.45n 0.0v 879.55n 5.0v 889.45n 5.0v 889.55n 5.0v 899.45n 5.0v 899.55n 5.0v 909.45n 5.0v 909.55n 5.0v 919.45n 5.0v 919.55n 5.0v 929.45n 5.0v 929.55n 5.0v 939.45n 5.0v 939.55n 5.0v 949.45n 5.0v 949.55n 0.0v 959.45n 0.0v 959.55n 0.0v 969.45n 0.0v 969.55n 0.0v 979.45n 0.0v 979.55n 0.0v 989.45n 0.0v 989.55n 5.0v 999.45n 5.0v 999.55n 5.0v 1009.45n 5.0v 1009.55n 5.0v 1019.45n 5.0v 1019.55n 5.0v 1029.45n 5.0v 1029.55n 0.0v 1039.45n 0.0v 1039.55n 5.0v 1049.45n 5.0v 1049.55n 5.0v 1059.45n 5.0v 1059.55n 5.0v 1069.45n 5.0v 1069.55n 5.0v 1079.45n 5.0v 1079.55n 5.0v 1089.45n 5.0v 1089.55n 5.0v 1099.45n 5.0v 1099.55n 5.0v 1109.45n 5.0v 1109.55n 5.0v 1119.45n 5.0v 1119.55n 5.0v 1129.45n 5.0v 1129.55n 5.0v 1139.45n 5.0v 1139.55n 5.0v 1149.45n 5.0v 1149.55n 5.0v 1159.45n 5.0v 1159.55n 5.0v 1169.45n 5.0v 1169.55n 5.0v 1179.45n 5.0v 1179.55n 0.0v 1189.45n 0.0v 1189.55n 0.0v 1199.45n 0.0v 1199.55n 0.0v 1209.45n 0.0v 1209.55n 0.0v 1219.45n 0.0v 1219.55n 0.0v 1229.45n 0.0v 1229.55n 0.0v 1239.45n 0.0v 1239.55n 5.0v 1249.45n 5.0v 1249.55n 5.0v 1259.45n 5.0v 1259.55n 5.0v 1269.45n 5.0v 1269.55n 5.0v 1279.45n 5.0v 1279.55n 5.0v 1289.45n 5.0v 1289.55n 5.0v 1299.45n 5.0v 1299.55n 5.0v 1309.45n 5.0v 1309.55n 5.0v 1319.45n 5.0v 1319.55n 5.0v 1329.45n 5.0v 1329.55n 5.0v 1339.45n 5.0v 1339.55n 5.0v 1349.45n 5.0v 1349.55n 5.0v 1359.45n 5.0v 1359.55n 0.0v 1369.45n 0.0v 1369.55n 0.0v 1379.45n 0.0v 1379.55n 0.0v 1389.45n 0.0v 1389.55n 0.0v 1399.45n 0.0v 1399.55n 0.0v 1409.45n 0.0v 1409.55n 0.0v 1419.45n 0.0v 1419.55n 0.0v 1429.45n 0.0v 1429.55n 0.0v 1439.45n 0.0v 1439.55n 0.0v 1449.45n 0.0v 1449.55n 0.0v 1459.45n 0.0v 1459.55n 0.0v 1469.45n 0.0v 1469.55n 0.0v 1479.45n 0.0v 1479.55n 0.0v 1489.45n 0.0v 1489.55n 0.0v 1499.45n 0.0v 1499.55n 0.0v 1509.45n 0.0v 1509.55n 0.0v 1519.45n 0.0v 1519.55n 0.0v 1529.45n 0.0v 1529.55n 0.0v 1539.45n 0.0v 1539.55n 0.0v 1549.45n 0.0v 1549.55n 0.0v 1559.45n 0.0v 1559.55n 0.0v 1569.45n 0.0v 1569.55n 0.0v 1579.45n 0.0v 1579.55n 0.0v 1589.45n 0.0v 1589.55n 0.0v 1599.45n 0.0v 1599.55n 0.0v 1609.45n 0.0v 1609.55n 0.0v 1619.45n 0.0v 1619.55n 0.0v 1629.45n 0.0v 1629.55n 0.0v 1639.45n 0.0v 1639.55n 0.0v 1649.45n 0.0v 1649.55n 0.0v 1659.45n 0.0v 1659.55n 0.0v 1669.45n 0.0v 1669.55n 5.0v 1679.45n 5.0v 1679.55n 5.0v 1689.45n 5.0v 1689.55n 5.0v 1699.45n 5.0v 1699.55n 5.0v 1709.45n 5.0v 1709.55n 5.0v 1719.45n 5.0v 1719.55n 5.0v 1729.45n 5.0v 1729.55n 5.0v 1739.45n 5.0v 1739.55n 5.0v 1749.45n 5.0v 1749.55n 5.0v 1759.45n 5.0v 1759.55n 5.0v 1769.45n 5.0v 1769.55n 5.0v 1779.45n 5.0v 1779.55n 5.0v 1789.45n 5.0v 1789.55n 5.0v 1799.45n 5.0v 1799.55n 5.0v 1809.45n 5.0v 1809.55n 5.0v 1819.45n 5.0v 1819.55n 5.0v 1829.45n 5.0v 1829.55n 5.0v 1839.45n 5.0v 1839.55n 5.0v 1849.45n 5.0v 1849.55n 5.0v 1859.45n 5.0v 1859.55n 5.0v 1869.45n 5.0v 1869.55n 5.0v 1879.45n 5.0v 1879.55n 5.0v 1889.45n 5.0v 1889.55n 5.0v 1899.45n 5.0v 1899.55n 5.0v 1909.45n 5.0v 1909.55n 5.0v 1919.45n 5.0v 1919.55n 5.0v 1929.45n 5.0v 1929.55n 5.0v 1939.45n 5.0v 1939.55n 5.0v 1949.45n 5.0v 1949.55n 5.0v 1959.45n 5.0v 1959.55n 5.0v 1969.45n 5.0v 1969.55n 0.0v 1979.45n 0.0v 1979.55n 0.0v 1989.45n 0.0v 1989.55n 0.0v 1999.45n 0.0v 1999.55n 0.0v 2009.45n 0.0v 2009.55n 0.0v 2019.45n 0.0v 2019.55n 0.0v 2029.45n 0.0v 2029.55n 0.0v 2039.45n 0.0v 2039.55n 0.0v 2049.45n 0.0v 2049.55n 0.0v )
* (time, data): [(0, 0), (10, 1), (20, 0), (30, 0), (40, 0), (50, 0), (60, 0), (70, 0), (80, 0), (90, 0), (100, 0), (110, 0), (120, 0), (130, 0), (140, 0), (150, 0), (160, 0), (170, 0), (180, 1), (190, 1), (200, 1), (210, 1), (220, 1), (230, 1), (240, 1), (250, 1), (260, 1), (270, 1), (280, 1), (290, 0), (300, 0), (310, 0), (320, 0), (330, 0), (340, 0), (350, 0), (360, 0), (370, 0), (380, 0), (390, 0), (400, 0), (410, 0), (420, 0), (430, 0), (440, 0), (450, 0), (460, 0), (470, 0), (480, 0), (490, 0), (500, 0), (510, 0), (520, 0), (530, 0), (540, 0), (550, 0), (560, 0), (570, 0), (580, 0), (590, 0), (600, 0), (610, 0), (620, 0), (630, 0), (640, 1), (650, 1), (660, 1), (670, 1), (680, 1), (690, 1), (700, 1), (710, 1), (720, 1), (730, 1), (740, 1), (750, 0), (760, 0), (770, 0), (780, 0), (790, 0), (800, 0), (810, 0), (820, 0), (830, 0), (840, 1), (850, 1), (860, 1), (870, 1), (880, 0), (890, 0), (900, 0), (910, 0), (920, 0), (930, 0), (940, 1), (950, 0), (960, 0), (970, 0), (980, 0), (990, 1), (1000, 1), (1010, 1), (1020, 1), (1030, 0), (1040, 1), (1050, 1), (1060, 1), (1070, 0), (1080, 0), (1090, 0), (1100, 0), (1110, 0), (1120, 0), (1130, 0), (1140, 0), (1150, 1), (1160, 1), (1170, 1), (1180, 1), (1190, 1), (1200, 1), (1210, 1), (1220, 0), (1230, 0), (1240, 0), (1250, 0), (1260, 0), (1270, 0), (1280, 1), (1290, 0), (1300, 0), (1310, 0), (1320, 0), (1330, 0), (1340, 0), (1350, 0), (1360, 1), (1370, 1), (1380, 1), (1390, 1), (1400, 1), (1410, 1), (1420, 1), (1430, 1), (1440, 1), (1450, 1), (1460, 1), (1470, 1), (1480, 1), (1490, 1), (1500, 1), (1510, 1), (1520, 1), (1530, 0), (1540, 0), (1550, 0), (1560, 0), (1570, 0), (1580, 0), (1590, 0), (1600, 0), (1610, 0), (1620, 0), (1630, 0), (1640, 0), (1650, 0), (1660, 0), (1670, 0), (1680, 0), (1690, 0), (1700, 0), (1710, 0), (1720, 1), (1730, 0), (1740, 1), (1750, 0), (1760, 0), (1770, 0), (1780, 0), (1790, 1), (1800, 1), (1810, 1), (1820, 1), (1830, 1), (1840, 1), (1850, 1), (1860, 1), (1870, 1), (1880, 1), (1890, 1), (1900, 1), (1910, 1), (1920, 1), (1930, 1), (1940, 1), (1950, 1), (1960, 1), (1970, 0), (1980, 0), (1990, 0), (2000, 0), (2010, 0), (2020, 0), (2030, 0), (2040, 0), (2050, 0)]
Vdin0_11  din0_11  0 PWL (0n 0.0v 9.45n 0.0v 9.55n 5.0v 19.45n 5.0v 19.55n 0.0v 29.45n 0.0v 29.55n 0.0v 39.45n 0.0v 39.55n 0.0v 49.45n 0.0v 49.55n 0.0v 59.45n 0.0v 59.55n 0.0v 69.45n 0.0v 69.55n 0.0v 79.45n 0.0v 79.55n 0.0v 89.45n 0.0v 89.55n 0.0v 99.45n 0.0v 99.55n 0.0v 109.45n 0.0v 109.55n 0.0v 119.45n 0.0v 119.55n 0.0v 129.45n 0.0v 129.55n 0.0v 139.45n 0.0v 139.55n 0.0v 149.45n 0.0v 149.55n 0.0v 159.45n 0.0v 159.55n 0.0v 169.45n 0.0v 169.55n 0.0v 179.45n 0.0v 179.55n 5.0v 189.45n 5.0v 189.55n 5.0v 199.45n 5.0v 199.55n 5.0v 209.45n 5.0v 209.55n 5.0v 219.45n 5.0v 219.55n 5.0v 229.45n 5.0v 229.55n 5.0v 239.45n 5.0v 239.55n 5.0v 249.45n 5.0v 249.55n 5.0v 259.45n 5.0v 259.55n 5.0v 269.45n 5.0v 269.55n 5.0v 279.45n 5.0v 279.55n 5.0v 289.45n 5.0v 289.55n 0.0v 299.45n 0.0v 299.55n 0.0v 309.45n 0.0v 309.55n 0.0v 319.45n 0.0v 319.55n 0.0v 329.45n 0.0v 329.55n 0.0v 339.45n 0.0v 339.55n 0.0v 349.45n 0.0v 349.55n 0.0v 359.45n 0.0v 359.55n 0.0v 369.45n 0.0v 369.55n 0.0v 379.45n 0.0v 379.55n 0.0v 389.45n 0.0v 389.55n 0.0v 399.45n 0.0v 399.55n 0.0v 409.45n 0.0v 409.55n 0.0v 419.45n 0.0v 419.55n 0.0v 429.45n 0.0v 429.55n 0.0v 439.45n 0.0v 439.55n 0.0v 449.45n 0.0v 449.55n 0.0v 459.45n 0.0v 459.55n 0.0v 469.45n 0.0v 469.55n 0.0v 479.45n 0.0v 479.55n 0.0v 489.45n 0.0v 489.55n 0.0v 499.45n 0.0v 499.55n 0.0v 509.45n 0.0v 509.55n 0.0v 519.45n 0.0v 519.55n 0.0v 529.45n 0.0v 529.55n 0.0v 539.45n 0.0v 539.55n 0.0v 549.45n 0.0v 549.55n 0.0v 559.45n 0.0v 559.55n 0.0v 569.45n 0.0v 569.55n 0.0v 579.45n 0.0v 579.55n 0.0v 589.45n 0.0v 589.55n 0.0v 599.45n 0.0v 599.55n 0.0v 609.45n 0.0v 609.55n 0.0v 619.45n 0.0v 619.55n 0.0v 629.45n 0.0v 629.55n 0.0v 639.45n 0.0v 639.55n 5.0v 649.45n 5.0v 649.55n 5.0v 659.45n 5.0v 659.55n 5.0v 669.45n 5.0v 669.55n 5.0v 679.45n 5.0v 679.55n 5.0v 689.45n 5.0v 689.55n 5.0v 699.45n 5.0v 699.55n 5.0v 709.45n 5.0v 709.55n 5.0v 719.45n 5.0v 719.55n 5.0v 729.45n 5.0v 729.55n 5.0v 739.45n 5.0v 739.55n 5.0v 749.45n 5.0v 749.55n 0.0v 759.45n 0.0v 759.55n 0.0v 769.45n 0.0v 769.55n 0.0v 779.45n 0.0v 779.55n 0.0v 789.45n 0.0v 789.55n 0.0v 799.45n 0.0v 799.55n 0.0v 809.45n 0.0v 809.55n 0.0v 819.45n 0.0v 819.55n 0.0v 829.45n 0.0v 829.55n 0.0v 839.45n 0.0v 839.55n 5.0v 849.45n 5.0v 849.55n 5.0v 859.45n 5.0v 859.55n 5.0v 869.45n 5.0v 869.55n 5.0v 879.45n 5.0v 879.55n 0.0v 889.45n 0.0v 889.55n 0.0v 899.45n 0.0v 899.55n 0.0v 909.45n 0.0v 909.55n 0.0v 919.45n 0.0v 919.55n 0.0v 929.45n 0.0v 929.55n 0.0v 939.45n 0.0v 939.55n 5.0v 949.45n 5.0v 949.55n 0.0v 959.45n 0.0v 959.55n 0.0v 969.45n 0.0v 969.55n 0.0v 979.45n 0.0v 979.55n 0.0v 989.45n 0.0v 989.55n 5.0v 999.45n 5.0v 999.55n 5.0v 1009.45n 5.0v 1009.55n 5.0v 1019.45n 5.0v 1019.55n 5.0v 1029.45n 5.0v 1029.55n 0.0v 1039.45n 0.0v 1039.55n 5.0v 1049.45n 5.0v 1049.55n 5.0v 1059.45n 5.0v 1059.55n 5.0v 1069.45n 5.0v 1069.55n 0.0v 1079.45n 0.0v 1079.55n 0.0v 1089.45n 0.0v 1089.55n 0.0v 1099.45n 0.0v 1099.55n 0.0v 1109.45n 0.0v 1109.55n 0.0v 1119.45n 0.0v 1119.55n 0.0v 1129.45n 0.0v 1129.55n 0.0v 1139.45n 0.0v 1139.55n 0.0v 1149.45n 0.0v 1149.55n 5.0v 1159.45n 5.0v 1159.55n 5.0v 1169.45n 5.0v 1169.55n 5.0v 1179.45n 5.0v 1179.55n 5.0v 1189.45n 5.0v 1189.55n 5.0v 1199.45n 5.0v 1199.55n 5.0v 1209.45n 5.0v 1209.55n 5.0v 1219.45n 5.0v 1219.55n 0.0v 1229.45n 0.0v 1229.55n 0.0v 1239.45n 0.0v 1239.55n 0.0v 1249.45n 0.0v 1249.55n 0.0v 1259.45n 0.0v 1259.55n 0.0v 1269.45n 0.0v 1269.55n 0.0v 1279.45n 0.0v 1279.55n 5.0v 1289.45n 5.0v 1289.55n 0.0v 1299.45n 0.0v 1299.55n 0.0v 1309.45n 0.0v 1309.55n 0.0v 1319.45n 0.0v 1319.55n 0.0v 1329.45n 0.0v 1329.55n 0.0v 1339.45n 0.0v 1339.55n 0.0v 1349.45n 0.0v 1349.55n 0.0v 1359.45n 0.0v 1359.55n 5.0v 1369.45n 5.0v 1369.55n 5.0v 1379.45n 5.0v 1379.55n 5.0v 1389.45n 5.0v 1389.55n 5.0v 1399.45n 5.0v 1399.55n 5.0v 1409.45n 5.0v 1409.55n 5.0v 1419.45n 5.0v 1419.55n 5.0v 1429.45n 5.0v 1429.55n 5.0v 1439.45n 5.0v 1439.55n 5.0v 1449.45n 5.0v 1449.55n 5.0v 1459.45n 5.0v 1459.55n 5.0v 1469.45n 5.0v 1469.55n 5.0v 1479.45n 5.0v 1479.55n 5.0v 1489.45n 5.0v 1489.55n 5.0v 1499.45n 5.0v 1499.55n 5.0v 1509.45n 5.0v 1509.55n 5.0v 1519.45n 5.0v 1519.55n 5.0v 1529.45n 5.0v 1529.55n 0.0v 1539.45n 0.0v 1539.55n 0.0v 1549.45n 0.0v 1549.55n 0.0v 1559.45n 0.0v 1559.55n 0.0v 1569.45n 0.0v 1569.55n 0.0v 1579.45n 0.0v 1579.55n 0.0v 1589.45n 0.0v 1589.55n 0.0v 1599.45n 0.0v 1599.55n 0.0v 1609.45n 0.0v 1609.55n 0.0v 1619.45n 0.0v 1619.55n 0.0v 1629.45n 0.0v 1629.55n 0.0v 1639.45n 0.0v 1639.55n 0.0v 1649.45n 0.0v 1649.55n 0.0v 1659.45n 0.0v 1659.55n 0.0v 1669.45n 0.0v 1669.55n 0.0v 1679.45n 0.0v 1679.55n 0.0v 1689.45n 0.0v 1689.55n 0.0v 1699.45n 0.0v 1699.55n 0.0v 1709.45n 0.0v 1709.55n 0.0v 1719.45n 0.0v 1719.55n 5.0v 1729.45n 5.0v 1729.55n 0.0v 1739.45n 0.0v 1739.55n 5.0v 1749.45n 5.0v 1749.55n 0.0v 1759.45n 0.0v 1759.55n 0.0v 1769.45n 0.0v 1769.55n 0.0v 1779.45n 0.0v 1779.55n 0.0v 1789.45n 0.0v 1789.55n 5.0v 1799.45n 5.0v 1799.55n 5.0v 1809.45n 5.0v 1809.55n 5.0v 1819.45n 5.0v 1819.55n 5.0v 1829.45n 5.0v 1829.55n 5.0v 1839.45n 5.0v 1839.55n 5.0v 1849.45n 5.0v 1849.55n 5.0v 1859.45n 5.0v 1859.55n 5.0v 1869.45n 5.0v 1869.55n 5.0v 1879.45n 5.0v 1879.55n 5.0v 1889.45n 5.0v 1889.55n 5.0v 1899.45n 5.0v 1899.55n 5.0v 1909.45n 5.0v 1909.55n 5.0v 1919.45n 5.0v 1919.55n 5.0v 1929.45n 5.0v 1929.55n 5.0v 1939.45n 5.0v 1939.55n 5.0v 1949.45n 5.0v 1949.55n 5.0v 1959.45n 5.0v 1959.55n 5.0v 1969.45n 5.0v 1969.55n 0.0v 1979.45n 0.0v 1979.55n 0.0v 1989.45n 0.0v 1989.55n 0.0v 1999.45n 0.0v 1999.55n 0.0v 2009.45n 0.0v 2009.55n 0.0v 2019.45n 0.0v 2019.55n 0.0v 2029.45n 0.0v 2029.55n 0.0v 2039.45n 0.0v 2039.55n 0.0v 2049.45n 0.0v 2049.55n 0.0v )
* (time, data): [(0, 0), (10, 0), (20, 0), (30, 1), (40, 1), (50, 1), (60, 1), (70, 1), (80, 1), (90, 1), (100, 1), (110, 1), (120, 1), (130, 0), (140, 0), (150, 0), (160, 0), (170, 0), (180, 0), (190, 0), (200, 0), (210, 0), (220, 0), (230, 0), (240, 0), (250, 0), (260, 0), (270, 0), (280, 0), (290, 1), (300, 0), (310, 0), (320, 0), (330, 0), (340, 0), (350, 0), (360, 1), (370, 1), (380, 1), (390, 1), (400, 1), (410, 1), (420, 0), (430, 0), (440, 0), (450, 0), (460, 0), (470, 0), (480, 0), (490, 0), (500, 1), (510, 1), (520, 1), (530, 1), (540, 1), (550, 1), (560, 1), (570, 1), (580, 1), (590, 1), (600, 1), (610, 1), (620, 1), (630, 1), (640, 1), (650, 1), (660, 1), (670, 1), (680, 1), (690, 1), (700, 0), (710, 0), (720, 0), (730, 0), (740, 0), (750, 0), (760, 0), (770, 0), (780, 0), (790, 0), (800, 0), (810, 0), (820, 0), (830, 0), (840, 1), (850, 1), (860, 1), (870, 1), (880, 0), (890, 0), (900, 0), (910, 0), (920, 0), (930, 0), (940, 1), (950, 1), (960, 1), (970, 1), (980, 1), (990, 0), (1000, 0), (1010, 0), (1020, 0), (1030, 1), (1040, 1), (1050, 1), (1060, 1), (1070, 0), (1080, 0), (1090, 0), (1100, 0), (1110, 0), (1120, 0), (1130, 0), (1140, 0), (1150, 0), (1160, 1), (1170, 1), (1180, 0), (1190, 0), (1200, 0), (1210, 1), (1220, 0), (1230, 0), (1240, 0), (1250, 0), (1260, 0), (1270, 0), (1280, 1), (1290, 0), (1300, 0), (1310, 0), (1320, 0), (1330, 0), (1340, 0), (1350, 0), (1360, 0), (1370, 0), (1380, 0), (1390, 0), (1400, 1), (1410, 1), (1420, 1), (1430, 1), (1440, 1), (1450, 1), (1460, 1), (1470, 1), (1480, 1), (1490, 1), (1500, 1), (1510, 1), (1520, 1), (1530, 1), (1540, 1), (1550, 1), (1560, 1), (1570, 1), (1580, 1), (1590, 1), (1600, 1), (1610, 1), (1620, 1), (1630, 1), (1640, 1), (1650, 1), (1660, 1), (1670, 0), (1680, 0), (1690, 0), (1700, 0), (1710, 0), (1720, 0), (1730, 0), (1740, 0), (1750, 0), (1760, 0), (1770, 0), (1780, 0), (1790, 1), (1800, 1), (1810, 1), (1820, 1), (1830, 1), (1840, 1), (1850, 1), (1860, 1), (1870, 1), (1880, 1), (1890, 1), (1900, 1), (1910, 1), (1920, 1), (1930, 1), (1940, 1), (1950, 1), (1960, 1), (1970, 1), (1980, 1), (1990, 1), (2000, 1), (2010, 1), (2020, 1), (2030, 1), (2040, 1), (2050, 1)]
Vdin0_12  din0_12  0 PWL (0n 0.0v 9.45n 0.0v 9.55n 0.0v 19.45n 0.0v 19.55n 0.0v 29.45n 0.0v 29.55n 5.0v 39.45n 5.0v 39.55n 5.0v 49.45n 5.0v 49.55n 5.0v 59.45n 5.0v 59.55n 5.0v 69.45n 5.0v 69.55n 5.0v 79.45n 5.0v 79.55n 5.0v 89.45n 5.0v 89.55n 5.0v 99.45n 5.0v 99.55n 5.0v 109.45n 5.0v 109.55n 5.0v 119.45n 5.0v 119.55n 5.0v 129.45n 5.0v 129.55n 0.0v 139.45n 0.0v 139.55n 0.0v 149.45n 0.0v 149.55n 0.0v 159.45n 0.0v 159.55n 0.0v 169.45n 0.0v 169.55n 0.0v 179.45n 0.0v 179.55n 0.0v 189.45n 0.0v 189.55n 0.0v 199.45n 0.0v 199.55n 0.0v 209.45n 0.0v 209.55n 0.0v 219.45n 0.0v 219.55n 0.0v 229.45n 0.0v 229.55n 0.0v 239.45n 0.0v 239.55n 0.0v 249.45n 0.0v 249.55n 0.0v 259.45n 0.0v 259.55n 0.0v 269.45n 0.0v 269.55n 0.0v 279.45n 0.0v 279.55n 0.0v 289.45n 0.0v 289.55n 5.0v 299.45n 5.0v 299.55n 0.0v 309.45n 0.0v 309.55n 0.0v 319.45n 0.0v 319.55n 0.0v 329.45n 0.0v 329.55n 0.0v 339.45n 0.0v 339.55n 0.0v 349.45n 0.0v 349.55n 0.0v 359.45n 0.0v 359.55n 5.0v 369.45n 5.0v 369.55n 5.0v 379.45n 5.0v 379.55n 5.0v 389.45n 5.0v 389.55n 5.0v 399.45n 5.0v 399.55n 5.0v 409.45n 5.0v 409.55n 5.0v 419.45n 5.0v 419.55n 0.0v 429.45n 0.0v 429.55n 0.0v 439.45n 0.0v 439.55n 0.0v 449.45n 0.0v 449.55n 0.0v 459.45n 0.0v 459.55n 0.0v 469.45n 0.0v 469.55n 0.0v 479.45n 0.0v 479.55n 0.0v 489.45n 0.0v 489.55n 0.0v 499.45n 0.0v 499.55n 5.0v 509.45n 5.0v 509.55n 5.0v 519.45n 5.0v 519.55n 5.0v 529.45n 5.0v 529.55n 5.0v 539.45n 5.0v 539.55n 5.0v 549.45n 5.0v 549.55n 5.0v 559.45n 5.0v 559.55n 5.0v 569.45n 5.0v 569.55n 5.0v 579.45n 5.0v 579.55n 5.0v 589.45n 5.0v 589.55n 5.0v 599.45n 5.0v 599.55n 5.0v 609.45n 5.0v 609.55n 5.0v 619.45n 5.0v 619.55n 5.0v 629.45n 5.0v 629.55n 5.0v 639.45n 5.0v 639.55n 5.0v 649.45n 5.0v 649.55n 5.0v 659.45n 5.0v 659.55n 5.0v 669.45n 5.0v 669.55n 5.0v 679.45n 5.0v 679.55n 5.0v 689.45n 5.0v 689.55n 5.0v 699.45n 5.0v 699.55n 0.0v 709.45n 0.0v 709.55n 0.0v 719.45n 0.0v 719.55n 0.0v 729.45n 0.0v 729.55n 0.0v 739.45n 0.0v 739.55n 0.0v 749.45n 0.0v 749.55n 0.0v 759.45n 0.0v 759.55n 0.0v 769.45n 0.0v 769.55n 0.0v 779.45n 0.0v 779.55n 0.0v 789.45n 0.0v 789.55n 0.0v 799.45n 0.0v 799.55n 0.0v 809.45n 0.0v 809.55n 0.0v 819.45n 0.0v 819.55n 0.0v 829.45n 0.0v 829.55n 0.0v 839.45n 0.0v 839.55n 5.0v 849.45n 5.0v 849.55n 5.0v 859.45n 5.0v 859.55n 5.0v 869.45n 5.0v 869.55n 5.0v 879.45n 5.0v 879.55n 0.0v 889.45n 0.0v 889.55n 0.0v 899.45n 0.0v 899.55n 0.0v 909.45n 0.0v 909.55n 0.0v 919.45n 0.0v 919.55n 0.0v 929.45n 0.0v 929.55n 0.0v 939.45n 0.0v 939.55n 5.0v 949.45n 5.0v 949.55n 5.0v 959.45n 5.0v 959.55n 5.0v 969.45n 5.0v 969.55n 5.0v 979.45n 5.0v 979.55n 5.0v 989.45n 5.0v 989.55n 0.0v 999.45n 0.0v 999.55n 0.0v 1009.45n 0.0v 1009.55n 0.0v 1019.45n 0.0v 1019.55n 0.0v 1029.45n 0.0v 1029.55n 5.0v 1039.45n 5.0v 1039.55n 5.0v 1049.45n 5.0v 1049.55n 5.0v 1059.45n 5.0v 1059.55n 5.0v 1069.45n 5.0v 1069.55n 0.0v 1079.45n 0.0v 1079.55n 0.0v 1089.45n 0.0v 1089.55n 0.0v 1099.45n 0.0v 1099.55n 0.0v 1109.45n 0.0v 1109.55n 0.0v 1119.45n 0.0v 1119.55n 0.0v 1129.45n 0.0v 1129.55n 0.0v 1139.45n 0.0v 1139.55n 0.0v 1149.45n 0.0v 1149.55n 0.0v 1159.45n 0.0v 1159.55n 5.0v 1169.45n 5.0v 1169.55n 5.0v 1179.45n 5.0v 1179.55n 0.0v 1189.45n 0.0v 1189.55n 0.0v 1199.45n 0.0v 1199.55n 0.0v 1209.45n 0.0v 1209.55n 5.0v 1219.45n 5.0v 1219.55n 0.0v 1229.45n 0.0v 1229.55n 0.0v 1239.45n 0.0v 1239.55n 0.0v 1249.45n 0.0v 1249.55n 0.0v 1259.45n 0.0v 1259.55n 0.0v 1269.45n 0.0v 1269.55n 0.0v 1279.45n 0.0v 1279.55n 5.0v 1289.45n 5.0v 1289.55n 0.0v 1299.45n 0.0v 1299.55n 0.0v 1309.45n 0.0v 1309.55n 0.0v 1319.45n 0.0v 1319.55n 0.0v 1329.45n 0.0v 1329.55n 0.0v 1339.45n 0.0v 1339.55n 0.0v 1349.45n 0.0v 1349.55n 0.0v 1359.45n 0.0v 1359.55n 0.0v 1369.45n 0.0v 1369.55n 0.0v 1379.45n 0.0v 1379.55n 0.0v 1389.45n 0.0v 1389.55n 0.0v 1399.45n 0.0v 1399.55n 5.0v 1409.45n 5.0v 1409.55n 5.0v 1419.45n 5.0v 1419.55n 5.0v 1429.45n 5.0v 1429.55n 5.0v 1439.45n 5.0v 1439.55n 5.0v 1449.45n 5.0v 1449.55n 5.0v 1459.45n 5.0v 1459.55n 5.0v 1469.45n 5.0v 1469.55n 5.0v 1479.45n 5.0v 1479.55n 5.0v 1489.45n 5.0v 1489.55n 5.0v 1499.45n 5.0v 1499.55n 5.0v 1509.45n 5.0v 1509.55n 5.0v 1519.45n 5.0v 1519.55n 5.0v 1529.45n 5.0v 1529.55n 5.0v 1539.45n 5.0v 1539.55n 5.0v 1549.45n 5.0v 1549.55n 5.0v 1559.45n 5.0v 1559.55n 5.0v 1569.45n 5.0v 1569.55n 5.0v 1579.45n 5.0v 1579.55n 5.0v 1589.45n 5.0v 1589.55n 5.0v 1599.45n 5.0v 1599.55n 5.0v 1609.45n 5.0v 1609.55n 5.0v 1619.45n 5.0v 1619.55n 5.0v 1629.45n 5.0v 1629.55n 5.0v 1639.45n 5.0v 1639.55n 5.0v 1649.45n 5.0v 1649.55n 5.0v 1659.45n 5.0v 1659.55n 5.0v 1669.45n 5.0v 1669.55n 0.0v 1679.45n 0.0v 1679.55n 0.0v 1689.45n 0.0v 1689.55n 0.0v 1699.45n 0.0v 1699.55n 0.0v 1709.45n 0.0v 1709.55n 0.0v 1719.45n 0.0v 1719.55n 0.0v 1729.45n 0.0v 1729.55n 0.0v 1739.45n 0.0v 1739.55n 0.0v 1749.45n 0.0v 1749.55n 0.0v 1759.45n 0.0v 1759.55n 0.0v 1769.45n 0.0v 1769.55n 0.0v 1779.45n 0.0v 1779.55n 0.0v 1789.45n 0.0v 1789.55n 5.0v 1799.45n 5.0v 1799.55n 5.0v 1809.45n 5.0v 1809.55n 5.0v 1819.45n 5.0v 1819.55n 5.0v 1829.45n 5.0v 1829.55n 5.0v 1839.45n 5.0v 1839.55n 5.0v 1849.45n 5.0v 1849.55n 5.0v 1859.45n 5.0v 1859.55n 5.0v 1869.45n 5.0v 1869.55n 5.0v 1879.45n 5.0v 1879.55n 5.0v 1889.45n 5.0v 1889.55n 5.0v 1899.45n 5.0v 1899.55n 5.0v 1909.45n 5.0v 1909.55n 5.0v 1919.45n 5.0v 1919.55n 5.0v 1929.45n 5.0v 1929.55n 5.0v 1939.45n 5.0v 1939.55n 5.0v 1949.45n 5.0v 1949.55n 5.0v 1959.45n 5.0v 1959.55n 5.0v 1969.45n 5.0v 1969.55n 5.0v 1979.45n 5.0v 1979.55n 5.0v 1989.45n 5.0v 1989.55n 5.0v 1999.45n 5.0v 1999.55n 5.0v 2009.45n 5.0v 2009.55n 5.0v 2019.45n 5.0v 2019.55n 5.0v 2029.45n 5.0v 2029.55n 5.0v 2039.45n 5.0v 2039.55n 5.0v 2049.45n 5.0v 2049.55n 5.0v )
* (time, data): [(0, 0), (10, 0), (20, 0), (30, 0), (40, 0), (50, 0), (60, 0), (70, 0), (80, 0), (90, 0), (100, 0), (110, 0), (120, 0), (130, 1), (140, 1), (150, 1), (160, 1), (170, 0), (180, 0), (190, 0), (200, 0), (210, 0), (220, 0), (230, 0), (240, 0), (250, 0), (260, 0), (270, 0), (280, 0), (290, 0), (300, 0), (310, 0), (320, 0), (330, 0), (340, 0), (350, 1), (360, 0), (370, 0), (380, 0), (390, 0), (400, 0), (410, 0), (420, 0), (430, 0), (440, 0), (450, 0), (460, 0), (470, 0), (480, 0), (490, 0), (500, 1), (510, 1), (520, 1), (530, 1), (540, 1), (550, 1), (560, 1), (570, 1), (580, 1), (590, 1), (600, 1), (610, 1), (620, 1), (630, 1), (640, 1), (650, 0), (660, 0), (670, 0), (680, 0), (690, 0), (700, 0), (710, 0), (720, 0), (730, 0), (740, 0), (750, 1), (760, 1), (770, 1), (780, 1), (790, 1), (800, 1), (810, 1), (820, 1), (830, 1), (840, 1), (850, 1), (860, 1), (870, 1), (880, 0), (890, 0), (900, 0), (910, 0), (920, 0), (930, 0), (940, 0), (950, 1), (960, 1), (970, 1), (980, 1), (990, 0), (1000, 0), (1010, 0), (1020, 0), (1030, 0), (1040, 1), (1050, 1), (1060, 1), (1070, 1), (1080, 1), (1090, 1), (1100, 1), (1110, 1), (1120, 1), (1130, 1), (1140, 1), (1150, 1), (1160, 0), (1170, 0), (1180, 0), (1190, 0), (1200, 0), (1210, 0), (1220, 0), (1230, 0), (1240, 0), (1250, 0), (1260, 0), (1270, 0), (1280, 1), (1290, 0), (1300, 0), (1310, 0), (1320, 1), (1330, 1), (1340, 1), (1350, 1), (1360, 1), (1370, 1), (1380, 1), (1390, 1), (1400, 1), (1410, 1), (1420, 1), (1430, 1), (1440, 1), (1450, 1), (1460, 1), (1470, 1), (1480, 1), (1490, 1), (1500, 1), (1510, 1), (1520, 1), (1530, 0), (1540, 0), (1550, 0), (1560, 0), (1570, 0), (1580, 0), (1590, 0), (1600, 0), (1610, 0), (1620, 0), (1630, 0), (1640, 0), (1650, 0), (1660, 0), (1670, 0), (1680, 0), (1690, 0), (1700, 0), (1710, 0), (1720, 1), (1730, 1), (1740, 0), (1750, 0), (1760, 0), (1770, 0), (1780, 0), (1790, 0), (1800, 0), (1810, 0), (1820, 0), (1830, 0), (1840, 0), (1850, 0), (1860, 0), (1870, 0), (1880, 0), (1890, 0), (1900, 0), (1910, 0), (1920, 0), (1930, 0), (1940, 0), (1950, 0), (1960, 0), (1970, 1), (1980, 1), (1990, 1), (2000, 1), (2010, 1), (2020, 1), (2030, 1), (2040, 1), (2050, 1)]
Vdin0_13  din0_13  0 PWL (0n 0.0v 9.45n 0.0v 9.55n 0.0v 19.45n 0.0v 19.55n 0.0v 29.45n 0.0v 29.55n 0.0v 39.45n 0.0v 39.55n 0.0v 49.45n 0.0v 49.55n 0.0v 59.45n 0.0v 59.55n 0.0v 69.45n 0.0v 69.55n 0.0v 79.45n 0.0v 79.55n 0.0v 89.45n 0.0v 89.55n 0.0v 99.45n 0.0v 99.55n 0.0v 109.45n 0.0v 109.55n 0.0v 119.45n 0.0v 119.55n 0.0v 129.45n 0.0v 129.55n 5.0v 139.45n 5.0v 139.55n 5.0v 149.45n 5.0v 149.55n 5.0v 159.45n 5.0v 159.55n 5.0v 169.45n 5.0v 169.55n 0.0v 179.45n 0.0v 179.55n 0.0v 189.45n 0.0v 189.55n 0.0v 199.45n 0.0v 199.55n 0.0v 209.45n 0.0v 209.55n 0.0v 219.45n 0.0v 219.55n 0.0v 229.45n 0.0v 229.55n 0.0v 239.45n 0.0v 239.55n 0.0v 249.45n 0.0v 249.55n 0.0v 259.45n 0.0v 259.55n 0.0v 269.45n 0.0v 269.55n 0.0v 279.45n 0.0v 279.55n 0.0v 289.45n 0.0v 289.55n 0.0v 299.45n 0.0v 299.55n 0.0v 309.45n 0.0v 309.55n 0.0v 319.45n 0.0v 319.55n 0.0v 329.45n 0.0v 329.55n 0.0v 339.45n 0.0v 339.55n 0.0v 349.45n 0.0v 349.55n 5.0v 359.45n 5.0v 359.55n 0.0v 369.45n 0.0v 369.55n 0.0v 379.45n 0.0v 379.55n 0.0v 389.45n 0.0v 389.55n 0.0v 399.45n 0.0v 399.55n 0.0v 409.45n 0.0v 409.55n 0.0v 419.45n 0.0v 419.55n 0.0v 429.45n 0.0v 429.55n 0.0v 439.45n 0.0v 439.55n 0.0v 449.45n 0.0v 449.55n 0.0v 459.45n 0.0v 459.55n 0.0v 469.45n 0.0v 469.55n 0.0v 479.45n 0.0v 479.55n 0.0v 489.45n 0.0v 489.55n 0.0v 499.45n 0.0v 499.55n 5.0v 509.45n 5.0v 509.55n 5.0v 519.45n 5.0v 519.55n 5.0v 529.45n 5.0v 529.55n 5.0v 539.45n 5.0v 539.55n 5.0v 549.45n 5.0v 549.55n 5.0v 559.45n 5.0v 559.55n 5.0v 569.45n 5.0v 569.55n 5.0v 579.45n 5.0v 579.55n 5.0v 589.45n 5.0v 589.55n 5.0v 599.45n 5.0v 599.55n 5.0v 609.45n 5.0v 609.55n 5.0v 619.45n 5.0v 619.55n 5.0v 629.45n 5.0v 629.55n 5.0v 639.45n 5.0v 639.55n 5.0v 649.45n 5.0v 649.55n 0.0v 659.45n 0.0v 659.55n 0.0v 669.45n 0.0v 669.55n 0.0v 679.45n 0.0v 679.55n 0.0v 689.45n 0.0v 689.55n 0.0v 699.45n 0.0v 699.55n 0.0v 709.45n 0.0v 709.55n 0.0v 719.45n 0.0v 719.55n 0.0v 729.45n 0.0v 729.55n 0.0v 739.45n 0.0v 739.55n 0.0v 749.45n 0.0v 749.55n 5.0v 759.45n 5.0v 759.55n 5.0v 769.45n 5.0v 769.55n 5.0v 779.45n 5.0v 779.55n 5.0v 789.45n 5.0v 789.55n 5.0v 799.45n 5.0v 799.55n 5.0v 809.45n 5.0v 809.55n 5.0v 819.45n 5.0v 819.55n 5.0v 829.45n 5.0v 829.55n 5.0v 839.45n 5.0v 839.55n 5.0v 849.45n 5.0v 849.55n 5.0v 859.45n 5.0v 859.55n 5.0v 869.45n 5.0v 869.55n 5.0v 879.45n 5.0v 879.55n 0.0v 889.45n 0.0v 889.55n 0.0v 899.45n 0.0v 899.55n 0.0v 909.45n 0.0v 909.55n 0.0v 919.45n 0.0v 919.55n 0.0v 929.45n 0.0v 929.55n 0.0v 939.45n 0.0v 939.55n 0.0v 949.45n 0.0v 949.55n 5.0v 959.45n 5.0v 959.55n 5.0v 969.45n 5.0v 969.55n 5.0v 979.45n 5.0v 979.55n 5.0v 989.45n 5.0v 989.55n 0.0v 999.45n 0.0v 999.55n 0.0v 1009.45n 0.0v 1009.55n 0.0v 1019.45n 0.0v 1019.55n 0.0v 1029.45n 0.0v 1029.55n 0.0v 1039.45n 0.0v 1039.55n 5.0v 1049.45n 5.0v 1049.55n 5.0v 1059.45n 5.0v 1059.55n 5.0v 1069.45n 5.0v 1069.55n 5.0v 1079.45n 5.0v 1079.55n 5.0v 1089.45n 5.0v 1089.55n 5.0v 1099.45n 5.0v 1099.55n 5.0v 1109.45n 5.0v 1109.55n 5.0v 1119.45n 5.0v 1119.55n 5.0v 1129.45n 5.0v 1129.55n 5.0v 1139.45n 5.0v 1139.55n 5.0v 1149.45n 5.0v 1149.55n 5.0v 1159.45n 5.0v 1159.55n 0.0v 1169.45n 0.0v 1169.55n 0.0v 1179.45n 0.0v 1179.55n 0.0v 1189.45n 0.0v 1189.55n 0.0v 1199.45n 0.0v 1199.55n 0.0v 1209.45n 0.0v 1209.55n 0.0v 1219.45n 0.0v 1219.55n 0.0v 1229.45n 0.0v 1229.55n 0.0v 1239.45n 0.0v 1239.55n 0.0v 1249.45n 0.0v 1249.55n 0.0v 1259.45n 0.0v 1259.55n 0.0v 1269.45n 0.0v 1269.55n 0.0v 1279.45n 0.0v 1279.55n 5.0v 1289.45n 5.0v 1289.55n 0.0v 1299.45n 0.0v 1299.55n 0.0v 1309.45n 0.0v 1309.55n 0.0v 1319.45n 0.0v 1319.55n 5.0v 1329.45n 5.0v 1329.55n 5.0v 1339.45n 5.0v 1339.55n 5.0v 1349.45n 5.0v 1349.55n 5.0v 1359.45n 5.0v 1359.55n 5.0v 1369.45n 5.0v 1369.55n 5.0v 1379.45n 5.0v 1379.55n 5.0v 1389.45n 5.0v 1389.55n 5.0v 1399.45n 5.0v 1399.55n 5.0v 1409.45n 5.0v 1409.55n 5.0v 1419.45n 5.0v 1419.55n 5.0v 1429.45n 5.0v 1429.55n 5.0v 1439.45n 5.0v 1439.55n 5.0v 1449.45n 5.0v 1449.55n 5.0v 1459.45n 5.0v 1459.55n 5.0v 1469.45n 5.0v 1469.55n 5.0v 1479.45n 5.0v 1479.55n 5.0v 1489.45n 5.0v 1489.55n 5.0v 1499.45n 5.0v 1499.55n 5.0v 1509.45n 5.0v 1509.55n 5.0v 1519.45n 5.0v 1519.55n 5.0v 1529.45n 5.0v 1529.55n 0.0v 1539.45n 0.0v 1539.55n 0.0v 1549.45n 0.0v 1549.55n 0.0v 1559.45n 0.0v 1559.55n 0.0v 1569.45n 0.0v 1569.55n 0.0v 1579.45n 0.0v 1579.55n 0.0v 1589.45n 0.0v 1589.55n 0.0v 1599.45n 0.0v 1599.55n 0.0v 1609.45n 0.0v 1609.55n 0.0v 1619.45n 0.0v 1619.55n 0.0v 1629.45n 0.0v 1629.55n 0.0v 1639.45n 0.0v 1639.55n 0.0v 1649.45n 0.0v 1649.55n 0.0v 1659.45n 0.0v 1659.55n 0.0v 1669.45n 0.0v 1669.55n 0.0v 1679.45n 0.0v 1679.55n 0.0v 1689.45n 0.0v 1689.55n 0.0v 1699.45n 0.0v 1699.55n 0.0v 1709.45n 0.0v 1709.55n 0.0v 1719.45n 0.0v 1719.55n 5.0v 1729.45n 5.0v 1729.55n 5.0v 1739.45n 5.0v 1739.55n 0.0v 1749.45n 0.0v 1749.55n 0.0v 1759.45n 0.0v 1759.55n 0.0v 1769.45n 0.0v 1769.55n 0.0v 1779.45n 0.0v 1779.55n 0.0v 1789.45n 0.0v 1789.55n 0.0v 1799.45n 0.0v 1799.55n 0.0v 1809.45n 0.0v 1809.55n 0.0v 1819.45n 0.0v 1819.55n 0.0v 1829.45n 0.0v 1829.55n 0.0v 1839.45n 0.0v 1839.55n 0.0v 1849.45n 0.0v 1849.55n 0.0v 1859.45n 0.0v 1859.55n 0.0v 1869.45n 0.0v 1869.55n 0.0v 1879.45n 0.0v 1879.55n 0.0v 1889.45n 0.0v 1889.55n 0.0v 1899.45n 0.0v 1899.55n 0.0v 1909.45n 0.0v 1909.55n 0.0v 1919.45n 0.0v 1919.55n 0.0v 1929.45n 0.0v 1929.55n 0.0v 1939.45n 0.0v 1939.55n 0.0v 1949.45n 0.0v 1949.55n 0.0v 1959.45n 0.0v 1959.55n 0.0v 1969.45n 0.0v 1969.55n 5.0v 1979.45n 5.0v 1979.55n 5.0v 1989.45n 5.0v 1989.55n 5.0v 1999.45n 5.0v 1999.55n 5.0v 2009.45n 5.0v 2009.55n 5.0v 2019.45n 5.0v 2019.55n 5.0v 2029.45n 5.0v 2029.55n 5.0v 2039.45n 5.0v 2039.55n 5.0v 2049.45n 5.0v 2049.55n 5.0v )
* (time, data): [(0, 0), (10, 1), (20, 1), (30, 1), (40, 1), (50, 1), (60, 1), (70, 1), (80, 1), (90, 1), (100, 1), (110, 1), (120, 0), (130, 1), (140, 1), (150, 1), (160, 1), (170, 1), (180, 1), (190, 1), (200, 1), (210, 1), (220, 1), (230, 1), (240, 1), (250, 1), (260, 1), (270, 1), (280, 1), (290, 1), (300, 1), (310, 1), (320, 1), (330, 1), (340, 1), (350, 0), (360, 1), (370, 1), (380, 1), (390, 1), (400, 1), (410, 1), (420, 0), (430, 0), (440, 0), (450, 1), (460, 1), (470, 1), (480, 1), (490, 1), (500, 0), (510, 0), (520, 0), (530, 0), (540, 0), (550, 0), (560, 0), (570, 0), (580, 0), (590, 0), (600, 0), (610, 0), (620, 0), (630, 0), (640, 0), (650, 1), (660, 1), (670, 1), (680, 1), (690, 1), (700, 1), (710, 1), (720, 1), (730, 1), (740, 1), (750, 1), (760, 1), (770, 1), (780, 1), (790, 1), (800, 1), (810, 1), (820, 1), (830, 1), (840, 1), (850, 1), (860, 1), (870, 1), (880, 1), (890, 1), (900, 1), (910, 1), (920, 1), (930, 1), (940, 0), (950, 1), (960, 1), (970, 1), (980, 1), (990, 1), (1000, 1), (1010, 1), (1020, 1), (1030, 1), (1040, 0), (1050, 0), (1060, 0), (1070, 1), (1080, 1), (1090, 1), (1100, 1), (1110, 1), (1120, 1), (1130, 1), (1140, 1), (1150, 1), (1160, 1), (1170, 1), (1180, 1), (1190, 1), (1200, 1), (1210, 1), (1220, 1), (1230, 1), (1240, 1), (1250, 1), (1260, 1), (1270, 1), (1280, 1), (1290, 1), (1300, 1), (1310, 1), (1320, 1), (1330, 1), (1340, 1), (1350, 1), (1360, 1), (1370, 1), (1380, 1), (1390, 1), (1400, 0), (1410, 0), (1420, 0), (1430, 0), (1440, 0), (1450, 0), (1460, 0), (1470, 0), (1480, 0), (1490, 0), (1500, 0), (1510, 0), (1520, 0), (1530, 0), (1540, 0), (1550, 0), (1560, 0), (1570, 0), (1580, 0), (1590, 0), (1600, 0), (1610, 0), (1620, 0), (1630, 0), (1640, 0), (1650, 0), (1660, 0), (1670, 0), (1680, 0), (1690, 0), (1700, 0), (1710, 0), (1720, 1), (1730, 0), (1740, 0), (1750, 0), (1760, 0), (1770, 0), (1780, 0), (1790, 0), (1800, 0), (1810, 0), (1820, 0), (1830, 0), (1840, 0), (1850, 0), (1860, 0), (1870, 0), (1880, 0), (1890, 0), (1900, 0), (1910, 0), (1920, 0), (1930, 0), (1940, 0), (1950, 0), (1960, 0), (1970, 1), (1980, 1), (1990, 1), (2000, 1), (2010, 1), (2020, 1), (2030, 1), (2040, 1), (2050, 1)]
Vdin0_14  din0_14  0 PWL (0n 0.0v 9.45n 0.0v 9.55n 5.0v 19.45n 5.0v 19.55n 5.0v 29.45n 5.0v 29.55n 5.0v 39.45n 5.0v 39.55n 5.0v 49.45n 5.0v 49.55n 5.0v 59.45n 5.0v 59.55n 5.0v 69.45n 5.0v 69.55n 5.0v 79.45n 5.0v 79.55n 5.0v 89.45n 5.0v 89.55n 5.0v 99.45n 5.0v 99.55n 5.0v 109.45n 5.0v 109.55n 5.0v 119.45n 5.0v 119.55n 0.0v 129.45n 0.0v 129.55n 5.0v 139.45n 5.0v 139.55n 5.0v 149.45n 5.0v 149.55n 5.0v 159.45n 5.0v 159.55n 5.0v 169.45n 5.0v 169.55n 5.0v 179.45n 5.0v 179.55n 5.0v 189.45n 5.0v 189.55n 5.0v 199.45n 5.0v 199.55n 5.0v 209.45n 5.0v 209.55n 5.0v 219.45n 5.0v 219.55n 5.0v 229.45n 5.0v 229.55n 5.0v 239.45n 5.0v 239.55n 5.0v 249.45n 5.0v 249.55n 5.0v 259.45n 5.0v 259.55n 5.0v 269.45n 5.0v 269.55n 5.0v 279.45n 5.0v 279.55n 5.0v 289.45n 5.0v 289.55n 5.0v 299.45n 5.0v 299.55n 5.0v 309.45n 5.0v 309.55n 5.0v 319.45n 5.0v 319.55n 5.0v 329.45n 5.0v 329.55n 5.0v 339.45n 5.0v 339.55n 5.0v 349.45n 5.0v 349.55n 0.0v 359.45n 0.0v 359.55n 5.0v 369.45n 5.0v 369.55n 5.0v 379.45n 5.0v 379.55n 5.0v 389.45n 5.0v 389.55n 5.0v 399.45n 5.0v 399.55n 5.0v 409.45n 5.0v 409.55n 5.0v 419.45n 5.0v 419.55n 0.0v 429.45n 0.0v 429.55n 0.0v 439.45n 0.0v 439.55n 0.0v 449.45n 0.0v 449.55n 5.0v 459.45n 5.0v 459.55n 5.0v 469.45n 5.0v 469.55n 5.0v 479.45n 5.0v 479.55n 5.0v 489.45n 5.0v 489.55n 5.0v 499.45n 5.0v 499.55n 0.0v 509.45n 0.0v 509.55n 0.0v 519.45n 0.0v 519.55n 0.0v 529.45n 0.0v 529.55n 0.0v 539.45n 0.0v 539.55n 0.0v 549.45n 0.0v 549.55n 0.0v 559.45n 0.0v 559.55n 0.0v 569.45n 0.0v 569.55n 0.0v 579.45n 0.0v 579.55n 0.0v 589.45n 0.0v 589.55n 0.0v 599.45n 0.0v 599.55n 0.0v 609.45n 0.0v 609.55n 0.0v 619.45n 0.0v 619.55n 0.0v 629.45n 0.0v 629.55n 0.0v 639.45n 0.0v 639.55n 0.0v 649.45n 0.0v 649.55n 5.0v 659.45n 5.0v 659.55n 5.0v 669.45n 5.0v 669.55n 5.0v 679.45n 5.0v 679.55n 5.0v 689.45n 5.0v 689.55n 5.0v 699.45n 5.0v 699.55n 5.0v 709.45n 5.0v 709.55n 5.0v 719.45n 5.0v 719.55n 5.0v 729.45n 5.0v 729.55n 5.0v 739.45n 5.0v 739.55n 5.0v 749.45n 5.0v 749.55n 5.0v 759.45n 5.0v 759.55n 5.0v 769.45n 5.0v 769.55n 5.0v 779.45n 5.0v 779.55n 5.0v 789.45n 5.0v 789.55n 5.0v 799.45n 5.0v 799.55n 5.0v 809.45n 5.0v 809.55n 5.0v 819.45n 5.0v 819.55n 5.0v 829.45n 5.0v 829.55n 5.0v 839.45n 5.0v 839.55n 5.0v 849.45n 5.0v 849.55n 5.0v 859.45n 5.0v 859.55n 5.0v 869.45n 5.0v 869.55n 5.0v 879.45n 5.0v 879.55n 5.0v 889.45n 5.0v 889.55n 5.0v 899.45n 5.0v 899.55n 5.0v 909.45n 5.0v 909.55n 5.0v 919.45n 5.0v 919.55n 5.0v 929.45n 5.0v 929.55n 5.0v 939.45n 5.0v 939.55n 0.0v 949.45n 0.0v 949.55n 5.0v 959.45n 5.0v 959.55n 5.0v 969.45n 5.0v 969.55n 5.0v 979.45n 5.0v 979.55n 5.0v 989.45n 5.0v 989.55n 5.0v 999.45n 5.0v 999.55n 5.0v 1009.45n 5.0v 1009.55n 5.0v 1019.45n 5.0v 1019.55n 5.0v 1029.45n 5.0v 1029.55n 5.0v 1039.45n 5.0v 1039.55n 0.0v 1049.45n 0.0v 1049.55n 0.0v 1059.45n 0.0v 1059.55n 0.0v 1069.45n 0.0v 1069.55n 5.0v 1079.45n 5.0v 1079.55n 5.0v 1089.45n 5.0v 1089.55n 5.0v 1099.45n 5.0v 1099.55n 5.0v 1109.45n 5.0v 1109.55n 5.0v 1119.45n 5.0v 1119.55n 5.0v 1129.45n 5.0v 1129.55n 5.0v 1139.45n 5.0v 1139.55n 5.0v 1149.45n 5.0v 1149.55n 5.0v 1159.45n 5.0v 1159.55n 5.0v 1169.45n 5.0v 1169.55n 5.0v 1179.45n 5.0v 1179.55n 5.0v 1189.45n 5.0v 1189.55n 5.0v 1199.45n 5.0v 1199.55n 5.0v 1209.45n 5.0v 1209.55n 5.0v 1219.45n 5.0v 1219.55n 5.0v 1229.45n 5.0v 1229.55n 5.0v 1239.45n 5.0v 1239.55n 5.0v 1249.45n 5.0v 1249.55n 5.0v 1259.45n 5.0v 1259.55n 5.0v 1269.45n 5.0v 1269.55n 5.0v 1279.45n 5.0v 1279.55n 5.0v 1289.45n 5.0v 1289.55n 5.0v 1299.45n 5.0v 1299.55n 5.0v 1309.45n 5.0v 1309.55n 5.0v 1319.45n 5.0v 1319.55n 5.0v 1329.45n 5.0v 1329.55n 5.0v 1339.45n 5.0v 1339.55n 5.0v 1349.45n 5.0v 1349.55n 5.0v 1359.45n 5.0v 1359.55n 5.0v 1369.45n 5.0v 1369.55n 5.0v 1379.45n 5.0v 1379.55n 5.0v 1389.45n 5.0v 1389.55n 5.0v 1399.45n 5.0v 1399.55n 0.0v 1409.45n 0.0v 1409.55n 0.0v 1419.45n 0.0v 1419.55n 0.0v 1429.45n 0.0v 1429.55n 0.0v 1439.45n 0.0v 1439.55n 0.0v 1449.45n 0.0v 1449.55n 0.0v 1459.45n 0.0v 1459.55n 0.0v 1469.45n 0.0v 1469.55n 0.0v 1479.45n 0.0v 1479.55n 0.0v 1489.45n 0.0v 1489.55n 0.0v 1499.45n 0.0v 1499.55n 0.0v 1509.45n 0.0v 1509.55n 0.0v 1519.45n 0.0v 1519.55n 0.0v 1529.45n 0.0v 1529.55n 0.0v 1539.45n 0.0v 1539.55n 0.0v 1549.45n 0.0v 1549.55n 0.0v 1559.45n 0.0v 1559.55n 0.0v 1569.45n 0.0v 1569.55n 0.0v 1579.45n 0.0v 1579.55n 0.0v 1589.45n 0.0v 1589.55n 0.0v 1599.45n 0.0v 1599.55n 0.0v 1609.45n 0.0v 1609.55n 0.0v 1619.45n 0.0v 1619.55n 0.0v 1629.45n 0.0v 1629.55n 0.0v 1639.45n 0.0v 1639.55n 0.0v 1649.45n 0.0v 1649.55n 0.0v 1659.45n 0.0v 1659.55n 0.0v 1669.45n 0.0v 1669.55n 0.0v 1679.45n 0.0v 1679.55n 0.0v 1689.45n 0.0v 1689.55n 0.0v 1699.45n 0.0v 1699.55n 0.0v 1709.45n 0.0v 1709.55n 0.0v 1719.45n 0.0v 1719.55n 5.0v 1729.45n 5.0v 1729.55n 0.0v 1739.45n 0.0v 1739.55n 0.0v 1749.45n 0.0v 1749.55n 0.0v 1759.45n 0.0v 1759.55n 0.0v 1769.45n 0.0v 1769.55n 0.0v 1779.45n 0.0v 1779.55n 0.0v 1789.45n 0.0v 1789.55n 0.0v 1799.45n 0.0v 1799.55n 0.0v 1809.45n 0.0v 1809.55n 0.0v 1819.45n 0.0v 1819.55n 0.0v 1829.45n 0.0v 1829.55n 0.0v 1839.45n 0.0v 1839.55n 0.0v 1849.45n 0.0v 1849.55n 0.0v 1859.45n 0.0v 1859.55n 0.0v 1869.45n 0.0v 1869.55n 0.0v 1879.45n 0.0v 1879.55n 0.0v 1889.45n 0.0v 1889.55n 0.0v 1899.45n 0.0v 1899.55n 0.0v 1909.45n 0.0v 1909.55n 0.0v 1919.45n 0.0v 1919.55n 0.0v 1929.45n 0.0v 1929.55n 0.0v 1939.45n 0.0v 1939.55n 0.0v 1949.45n 0.0v 1949.55n 0.0v 1959.45n 0.0v 1959.55n 0.0v 1969.45n 0.0v 1969.55n 5.0v 1979.45n 5.0v 1979.55n 5.0v 1989.45n 5.0v 1989.55n 5.0v 1999.45n 5.0v 1999.55n 5.0v 2009.45n 5.0v 2009.55n 5.0v 2019.45n 5.0v 2019.55n 5.0v 2029.45n 5.0v 2029.55n 5.0v 2039.45n 5.0v 2039.55n 5.0v 2049.45n 5.0v 2049.55n 5.0v )
* (time, data): [(0, 0), (10, 1), (20, 1), (30, 0), (40, 0), (50, 0), (60, 0), (70, 0), (80, 0), (90, 0), (100, 0), (110, 0), (120, 0), (130, 0), (140, 0), (150, 0), (160, 0), (170, 1), (180, 1), (190, 1), (200, 1), (210, 1), (220, 1), (230, 1), (240, 1), (250, 1), (260, 1), (270, 1), (280, 1), (290, 0), (300, 1), (310, 1), (320, 1), (330, 1), (340, 1), (350, 1), (360, 1), (370, 1), (380, 1), (390, 1), (400, 1), (410, 1), (420, 0), (430, 0), (440, 0), (450, 1), (460, 1), (470, 1), (480, 1), (490, 1), (500, 1), (510, 1), (520, 1), (530, 1), (540, 1), (550, 1), (560, 1), (570, 1), (580, 1), (590, 1), (600, 1), (610, 1), (620, 1), (630, 1), (640, 1), (650, 1), (660, 1), (670, 1), (680, 1), (690, 1), (700, 1), (710, 1), (720, 1), (730, 1), (740, 1), (750, 1), (760, 1), (770, 1), (780, 1), (790, 1), (800, 1), (810, 1), (820, 1), (830, 1), (840, 0), (850, 0), (860, 0), (870, 0), (880, 0), (890, 0), (900, 0), (910, 0), (920, 0), (930, 0), (940, 0), (950, 0), (960, 0), (970, 0), (980, 0), (990, 0), (1000, 0), (1010, 0), (1020, 0), (1030, 0), (1040, 0), (1050, 0), (1060, 0), (1070, 0), (1080, 0), (1090, 0), (1100, 0), (1110, 0), (1120, 0), (1130, 0), (1140, 0), (1150, 0), (1160, 1), (1170, 1), (1180, 0), (1190, 0), (1200, 0), (1210, 0), (1220, 1), (1230, 1), (1240, 1), (1250, 1), (1260, 1), (1270, 1), (1280, 1), (1290, 0), (1300, 0), (1310, 0), (1320, 1), (1330, 1), (1340, 1), (1350, 1), (1360, 0), (1370, 0), (1380, 0), (1390, 0), (1400, 1), (1410, 1), (1420, 1), (1430, 1), (1440, 1), (1450, 1), (1460, 1), (1470, 1), (1480, 1), (1490, 1), (1500, 1), (1510, 1), (1520, 1), (1530, 1), (1540, 1), (1550, 1), (1560, 1), (1570, 1), (1580, 1), (1590, 1), (1600, 1), (1610, 1), (1620, 1), (1630, 1), (1640, 1), (1650, 1), (1660, 1), (1670, 0), (1680, 0), (1690, 0), (1700, 0), (1710, 0), (1720, 0), (1730, 1), (1740, 0), (1750, 1), (1760, 1), (1770, 1), (1780, 1), (1790, 0), (1800, 0), (1810, 1), (1820, 1), (1830, 1), (1840, 1), (1850, 1), (1860, 1), (1870, 1), (1880, 1), (1890, 1), (1900, 1), (1910, 1), (1920, 1), (1930, 1), (1940, 1), (1950, 1), (1960, 1), (1970, 0), (1980, 0), (1990, 0), (2000, 0), (2010, 0), (2020, 0), (2030, 0), (2040, 0), (2050, 0)]
Vdin0_15  din0_15  0 PWL (0n 0.0v 9.45n 0.0v 9.55n 5.0v 19.45n 5.0v 19.55n 5.0v 29.45n 5.0v 29.55n 0.0v 39.45n 0.0v 39.55n 0.0v 49.45n 0.0v 49.55n 0.0v 59.45n 0.0v 59.55n 0.0v 69.45n 0.0v 69.55n 0.0v 79.45n 0.0v 79.55n 0.0v 89.45n 0.0v 89.55n 0.0v 99.45n 0.0v 99.55n 0.0v 109.45n 0.0v 109.55n 0.0v 119.45n 0.0v 119.55n 0.0v 129.45n 0.0v 129.55n 0.0v 139.45n 0.0v 139.55n 0.0v 149.45n 0.0v 149.55n 0.0v 159.45n 0.0v 159.55n 0.0v 169.45n 0.0v 169.55n 5.0v 179.45n 5.0v 179.55n 5.0v 189.45n 5.0v 189.55n 5.0v 199.45n 5.0v 199.55n 5.0v 209.45n 5.0v 209.55n 5.0v 219.45n 5.0v 219.55n 5.0v 229.45n 5.0v 229.55n 5.0v 239.45n 5.0v 239.55n 5.0v 249.45n 5.0v 249.55n 5.0v 259.45n 5.0v 259.55n 5.0v 269.45n 5.0v 269.55n 5.0v 279.45n 5.0v 279.55n 5.0v 289.45n 5.0v 289.55n 0.0v 299.45n 0.0v 299.55n 5.0v 309.45n 5.0v 309.55n 5.0v 319.45n 5.0v 319.55n 5.0v 329.45n 5.0v 329.55n 5.0v 339.45n 5.0v 339.55n 5.0v 349.45n 5.0v 349.55n 5.0v 359.45n 5.0v 359.55n 5.0v 369.45n 5.0v 369.55n 5.0v 379.45n 5.0v 379.55n 5.0v 389.45n 5.0v 389.55n 5.0v 399.45n 5.0v 399.55n 5.0v 409.45n 5.0v 409.55n 5.0v 419.45n 5.0v 419.55n 0.0v 429.45n 0.0v 429.55n 0.0v 439.45n 0.0v 439.55n 0.0v 449.45n 0.0v 449.55n 5.0v 459.45n 5.0v 459.55n 5.0v 469.45n 5.0v 469.55n 5.0v 479.45n 5.0v 479.55n 5.0v 489.45n 5.0v 489.55n 5.0v 499.45n 5.0v 499.55n 5.0v 509.45n 5.0v 509.55n 5.0v 519.45n 5.0v 519.55n 5.0v 529.45n 5.0v 529.55n 5.0v 539.45n 5.0v 539.55n 5.0v 549.45n 5.0v 549.55n 5.0v 559.45n 5.0v 559.55n 5.0v 569.45n 5.0v 569.55n 5.0v 579.45n 5.0v 579.55n 5.0v 589.45n 5.0v 589.55n 5.0v 599.45n 5.0v 599.55n 5.0v 609.45n 5.0v 609.55n 5.0v 619.45n 5.0v 619.55n 5.0v 629.45n 5.0v 629.55n 5.0v 639.45n 5.0v 639.55n 5.0v 649.45n 5.0v 649.55n 5.0v 659.45n 5.0v 659.55n 5.0v 669.45n 5.0v 669.55n 5.0v 679.45n 5.0v 679.55n 5.0v 689.45n 5.0v 689.55n 5.0v 699.45n 5.0v 699.55n 5.0v 709.45n 5.0v 709.55n 5.0v 719.45n 5.0v 719.55n 5.0v 729.45n 5.0v 729.55n 5.0v 739.45n 5.0v 739.55n 5.0v 749.45n 5.0v 749.55n 5.0v 759.45n 5.0v 759.55n 5.0v 769.45n 5.0v 769.55n 5.0v 779.45n 5.0v 779.55n 5.0v 789.45n 5.0v 789.55n 5.0v 799.45n 5.0v 799.55n 5.0v 809.45n 5.0v 809.55n 5.0v 819.45n 5.0v 819.55n 5.0v 829.45n 5.0v 829.55n 5.0v 839.45n 5.0v 839.55n 0.0v 849.45n 0.0v 849.55n 0.0v 859.45n 0.0v 859.55n 0.0v 869.45n 0.0v 869.55n 0.0v 879.45n 0.0v 879.55n 0.0v 889.45n 0.0v 889.55n 0.0v 899.45n 0.0v 899.55n 0.0v 909.45n 0.0v 909.55n 0.0v 919.45n 0.0v 919.55n 0.0v 929.45n 0.0v 929.55n 0.0v 939.45n 0.0v 939.55n 0.0v 949.45n 0.0v 949.55n 0.0v 959.45n 0.0v 959.55n 0.0v 969.45n 0.0v 969.55n 0.0v 979.45n 0.0v 979.55n 0.0v 989.45n 0.0v 989.55n 0.0v 999.45n 0.0v 999.55n 0.0v 1009.45n 0.0v 1009.55n 0.0v 1019.45n 0.0v 1019.55n 0.0v 1029.45n 0.0v 1029.55n 0.0v 1039.45n 0.0v 1039.55n 0.0v 1049.45n 0.0v 1049.55n 0.0v 1059.45n 0.0v 1059.55n 0.0v 1069.45n 0.0v 1069.55n 0.0v 1079.45n 0.0v 1079.55n 0.0v 1089.45n 0.0v 1089.55n 0.0v 1099.45n 0.0v 1099.55n 0.0v 1109.45n 0.0v 1109.55n 0.0v 1119.45n 0.0v 1119.55n 0.0v 1129.45n 0.0v 1129.55n 0.0v 1139.45n 0.0v 1139.55n 0.0v 1149.45n 0.0v 1149.55n 0.0v 1159.45n 0.0v 1159.55n 5.0v 1169.45n 5.0v 1169.55n 5.0v 1179.45n 5.0v 1179.55n 0.0v 1189.45n 0.0v 1189.55n 0.0v 1199.45n 0.0v 1199.55n 0.0v 1209.45n 0.0v 1209.55n 0.0v 1219.45n 0.0v 1219.55n 5.0v 1229.45n 5.0v 1229.55n 5.0v 1239.45n 5.0v 1239.55n 5.0v 1249.45n 5.0v 1249.55n 5.0v 1259.45n 5.0v 1259.55n 5.0v 1269.45n 5.0v 1269.55n 5.0v 1279.45n 5.0v 1279.55n 5.0v 1289.45n 5.0v 1289.55n 0.0v 1299.45n 0.0v 1299.55n 0.0v 1309.45n 0.0v 1309.55n 0.0v 1319.45n 0.0v 1319.55n 5.0v 1329.45n 5.0v 1329.55n 5.0v 1339.45n 5.0v 1339.55n 5.0v 1349.45n 5.0v 1349.55n 5.0v 1359.45n 5.0v 1359.55n 0.0v 1369.45n 0.0v 1369.55n 0.0v 1379.45n 0.0v 1379.55n 0.0v 1389.45n 0.0v 1389.55n 0.0v 1399.45n 0.0v 1399.55n 5.0v 1409.45n 5.0v 1409.55n 5.0v 1419.45n 5.0v 1419.55n 5.0v 1429.45n 5.0v 1429.55n 5.0v 1439.45n 5.0v 1439.55n 5.0v 1449.45n 5.0v 1449.55n 5.0v 1459.45n 5.0v 1459.55n 5.0v 1469.45n 5.0v 1469.55n 5.0v 1479.45n 5.0v 1479.55n 5.0v 1489.45n 5.0v 1489.55n 5.0v 1499.45n 5.0v 1499.55n 5.0v 1509.45n 5.0v 1509.55n 5.0v 1519.45n 5.0v 1519.55n 5.0v 1529.45n 5.0v 1529.55n 5.0v 1539.45n 5.0v 1539.55n 5.0v 1549.45n 5.0v 1549.55n 5.0v 1559.45n 5.0v 1559.55n 5.0v 1569.45n 5.0v 1569.55n 5.0v 1579.45n 5.0v 1579.55n 5.0v 1589.45n 5.0v 1589.55n 5.0v 1599.45n 5.0v 1599.55n 5.0v 1609.45n 5.0v 1609.55n 5.0v 1619.45n 5.0v 1619.55n 5.0v 1629.45n 5.0v 1629.55n 5.0v 1639.45n 5.0v 1639.55n 5.0v 1649.45n 5.0v 1649.55n 5.0v 1659.45n 5.0v 1659.55n 5.0v 1669.45n 5.0v 1669.55n 0.0v 1679.45n 0.0v 1679.55n 0.0v 1689.45n 0.0v 1689.55n 0.0v 1699.45n 0.0v 1699.55n 0.0v 1709.45n 0.0v 1709.55n 0.0v 1719.45n 0.0v 1719.55n 0.0v 1729.45n 0.0v 1729.55n 5.0v 1739.45n 5.0v 1739.55n 0.0v 1749.45n 0.0v 1749.55n 5.0v 1759.45n 5.0v 1759.55n 5.0v 1769.45n 5.0v 1769.55n 5.0v 1779.45n 5.0v 1779.55n 5.0v 1789.45n 5.0v 1789.55n 0.0v 1799.45n 0.0v 1799.55n 0.0v 1809.45n 0.0v 1809.55n 5.0v 1819.45n 5.0v 1819.55n 5.0v 1829.45n 5.0v 1829.55n 5.0v 1839.45n 5.0v 1839.55n 5.0v 1849.45n 5.0v 1849.55n 5.0v 1859.45n 5.0v 1859.55n 5.0v 1869.45n 5.0v 1869.55n 5.0v 1879.45n 5.0v 1879.55n 5.0v 1889.45n 5.0v 1889.55n 5.0v 1899.45n 5.0v 1899.55n 5.0v 1909.45n 5.0v 1909.55n 5.0v 1919.45n 5.0v 1919.55n 5.0v 1929.45n 5.0v 1929.55n 5.0v 1939.45n 5.0v 1939.55n 5.0v 1949.45n 5.0v 1949.55n 5.0v 1959.45n 5.0v 1959.55n 5.0v 1969.45n 5.0v 1969.55n 0.0v 1979.45n 0.0v 1979.55n 0.0v 1989.45n 0.0v 1989.55n 0.0v 1999.45n 0.0v 1999.55n 0.0v 2009.45n 0.0v 2009.55n 0.0v 2019.45n 0.0v 2019.55n 0.0v 2029.45n 0.0v 2029.55n 0.0v 2039.45n 0.0v 2039.55n 0.0v 2049.45n 0.0v 2049.55n 0.0v )
* (time, data): [(0, 0), (10, 0), (20, 0), (30, 0), (40, 0), (50, 0), (60, 0), (70, 0), (80, 0), (90, 0), (100, 0), (110, 0), (120, 0), (130, 0), (140, 0), (150, 0), (160, 0), (170, 0), (180, 0), (190, 0), (200, 0), (210, 0), (220, 0), (230, 0), (240, 0), (250, 0), (260, 0), (270, 0), (280, 0), (290, 0), (300, 0), (310, 0), (320, 0), (330, 0), (340, 0), (350, 0), (360, 0), (370, 0), (380, 0), (390, 0), (400, 0), (410, 0), (420, 0), (430, 0), (440, 0), (450, 0), (460, 0), (470, 0), (480, 0), (490, 0), (500, 0), (510, 0), (520, 0), (530, 0), (540, 0), (550, 0), (560, 0), (570, 0), (580, 0), (590, 0), (600, 0), (610, 0), (620, 0), (630, 0), (640, 0), (650, 0), (660, 0), (670, 0), (680, 0), (690, 0), (700, 0), (710, 0), (720, 0), (730, 0), (740, 0), (750, 0), (760, 0), (770, 0), (780, 0), (790, 0), (800, 0), (810, 0), (820, 0), (830, 0), (840, 0), (850, 0), (860, 0), (870, 0), (880, 0), (890, 0), (900, 0), (910, 0), (920, 0), (930, 0), (940, 0), (950, 0), (960, 0), (970, 0), (980, 0), (990, 0), (1000, 0), (1010, 0), (1020, 0), (1030, 0), (1040, 0), (1050, 0), (1060, 0), (1070, 0), (1080, 0), (1090, 0), (1100, 0), (1110, 0), (1120, 0), (1130, 0), (1140, 0), (1150, 0), (1160, 0), (1170, 0), (1180, 0), (1190, 0), (1200, 0), (1210, 0), (1220, 0), (1230, 0), (1240, 0), (1250, 0), (1260, 0), (1270, 0), (1280, 0), (1290, 0), (1300, 0), (1310, 0), (1320, 0), (1330, 0), (1340, 0), (1350, 0), (1360, 0), (1370, 0), (1380, 0), (1390, 0), (1400, 0), (1410, 0), (1420, 0), (1430, 0), (1440, 0), (1450, 0), (1460, 0), (1470, 0), (1480, 0), (1490, 0), (1500, 0), (1510, 0), (1520, 0), (1530, 0), (1540, 0), (1550, 0), (1560, 0), (1570, 0), (1580, 0), (1590, 0), (1600, 0), (1610, 0), (1620, 0), (1630, 0), (1640, 0), (1650, 0), (1660, 0), (1670, 0), (1680, 0), (1690, 0), (1700, 0), (1710, 0), (1720, 0), (1730, 0), (1740, 0), (1750, 0), (1760, 0), (1770, 0), (1780, 0), (1790, 0), (1800, 0), (1810, 0), (1820, 0), (1830, 0), (1840, 0), (1850, 0), (1860, 0), (1870, 0), (1880, 0), (1890, 0), (1900, 0), (1910, 0), (1920, 0), (1930, 0), (1940, 0), (1950, 0), (1960, 0), (1970, 0), (1980, 0), (1990, 0), (2000, 0), (2010, 0), (2020, 0), (2030, 0), (2040, 0), (2050, 0)]
Va0_0  a0_0  0 PWL (0n 0.0v 9.45n 0.0v 9.55n 0.0v 19.45n 0.0v 19.55n 0.0v 29.45n 0.0v 29.55n 0.0v 39.45n 0.0v 39.55n 0.0v 49.45n 0.0v 49.55n 0.0v 59.45n 0.0v 59.55n 0.0v 69.45n 0.0v 69.55n 0.0v 79.45n 0.0v 79.55n 0.0v 89.45n 0.0v 89.55n 0.0v 99.45n 0.0v 99.55n 0.0v 109.45n 0.0v 109.55n 0.0v 119.45n 0.0v 119.55n 0.0v 129.45n 0.0v 129.55n 0.0v 139.45n 0.0v 139.55n 0.0v 149.45n 0.0v 149.55n 0.0v 159.45n 0.0v 159.55n 0.0v 169.45n 0.0v 169.55n 0.0v 179.45n 0.0v 179.55n 0.0v 189.45n 0.0v 189.55n 0.0v 199.45n 0.0v 199.55n 0.0v 209.45n 0.0v 209.55n 0.0v 219.45n 0.0v 219.55n 0.0v 229.45n 0.0v 229.55n 0.0v 239.45n 0.0v 239.55n 0.0v 249.45n 0.0v 249.55n 0.0v 259.45n 0.0v 259.55n 0.0v 269.45n 0.0v 269.55n 0.0v 279.45n 0.0v 279.55n 0.0v 289.45n 0.0v 289.55n 0.0v 299.45n 0.0v 299.55n 0.0v 309.45n 0.0v 309.55n 0.0v 319.45n 0.0v 319.55n 0.0v 329.45n 0.0v 329.55n 0.0v 339.45n 0.0v 339.55n 0.0v 349.45n 0.0v 349.55n 0.0v 359.45n 0.0v 359.55n 0.0v 369.45n 0.0v 369.55n 0.0v 379.45n 0.0v 379.55n 0.0v 389.45n 0.0v 389.55n 0.0v 399.45n 0.0v 399.55n 0.0v 409.45n 0.0v 409.55n 0.0v 419.45n 0.0v 419.55n 0.0v 429.45n 0.0v 429.55n 0.0v 439.45n 0.0v 439.55n 0.0v 449.45n 0.0v 449.55n 0.0v 459.45n 0.0v 459.55n 0.0v 469.45n 0.0v 469.55n 0.0v 479.45n 0.0v 479.55n 0.0v 489.45n 0.0v 489.55n 0.0v 499.45n 0.0v 499.55n 0.0v 509.45n 0.0v 509.55n 0.0v 519.45n 0.0v 519.55n 0.0v 529.45n 0.0v 529.55n 0.0v 539.45n 0.0v 539.55n 0.0v 549.45n 0.0v 549.55n 0.0v 559.45n 0.0v 559.55n 0.0v 569.45n 0.0v 569.55n 0.0v 579.45n 0.0v 579.55n 0.0v 589.45n 0.0v 589.55n 0.0v 599.45n 0.0v 599.55n 0.0v 609.45n 0.0v 609.55n 0.0v 619.45n 0.0v 619.55n 0.0v 629.45n 0.0v 629.55n 0.0v 639.45n 0.0v 639.55n 0.0v 649.45n 0.0v 649.55n 0.0v 659.45n 0.0v 659.55n 0.0v 669.45n 0.0v 669.55n 0.0v 679.45n 0.0v 679.55n 0.0v 689.45n 0.0v 689.55n 0.0v 699.45n 0.0v 699.55n 0.0v 709.45n 0.0v 709.55n 0.0v 719.45n 0.0v 719.55n 0.0v 729.45n 0.0v 729.55n 0.0v 739.45n 0.0v 739.55n 0.0v 749.45n 0.0v 749.55n 0.0v 759.45n 0.0v 759.55n 0.0v 769.45n 0.0v 769.55n 0.0v 779.45n 0.0v 779.55n 0.0v 789.45n 0.0v 789.55n 0.0v 799.45n 0.0v 799.55n 0.0v 809.45n 0.0v 809.55n 0.0v 819.45n 0.0v 819.55n 0.0v 829.45n 0.0v 829.55n 0.0v 839.45n 0.0v 839.55n 0.0v 849.45n 0.0v 849.55n 0.0v 859.45n 0.0v 859.55n 0.0v 869.45n 0.0v 869.55n 0.0v 879.45n 0.0v 879.55n 0.0v 889.45n 0.0v 889.55n 0.0v 899.45n 0.0v 899.55n 0.0v 909.45n 0.0v 909.55n 0.0v 919.45n 0.0v 919.55n 0.0v 929.45n 0.0v 929.55n 0.0v 939.45n 0.0v 939.55n 0.0v 949.45n 0.0v 949.55n 0.0v 959.45n 0.0v 959.55n 0.0v 969.45n 0.0v 969.55n 0.0v 979.45n 0.0v 979.55n 0.0v 989.45n 0.0v 989.55n 0.0v 999.45n 0.0v 999.55n 0.0v 1009.45n 0.0v 1009.55n 0.0v 1019.45n 0.0v 1019.55n 0.0v 1029.45n 0.0v 1029.55n 0.0v 1039.45n 0.0v 1039.55n 0.0v 1049.45n 0.0v 1049.55n 0.0v 1059.45n 0.0v 1059.55n 0.0v 1069.45n 0.0v 1069.55n 0.0v 1079.45n 0.0v 1079.55n 0.0v 1089.45n 0.0v 1089.55n 0.0v 1099.45n 0.0v 1099.55n 0.0v 1109.45n 0.0v 1109.55n 0.0v 1119.45n 0.0v 1119.55n 0.0v 1129.45n 0.0v 1129.55n 0.0v 1139.45n 0.0v 1139.55n 0.0v 1149.45n 0.0v 1149.55n 0.0v 1159.45n 0.0v 1159.55n 0.0v 1169.45n 0.0v 1169.55n 0.0v 1179.45n 0.0v 1179.55n 0.0v 1189.45n 0.0v 1189.55n 0.0v 1199.45n 0.0v 1199.55n 0.0v 1209.45n 0.0v 1209.55n 0.0v 1219.45n 0.0v 1219.55n 0.0v 1229.45n 0.0v 1229.55n 0.0v 1239.45n 0.0v 1239.55n 0.0v 1249.45n 0.0v 1249.55n 0.0v 1259.45n 0.0v 1259.55n 0.0v 1269.45n 0.0v 1269.55n 0.0v 1279.45n 0.0v 1279.55n 0.0v 1289.45n 0.0v 1289.55n 0.0v 1299.45n 0.0v 1299.55n 0.0v 1309.45n 0.0v 1309.55n 0.0v 1319.45n 0.0v 1319.55n 0.0v 1329.45n 0.0v 1329.55n 0.0v 1339.45n 0.0v 1339.55n 0.0v 1349.45n 0.0v 1349.55n 0.0v 1359.45n 0.0v 1359.55n 0.0v 1369.45n 0.0v 1369.55n 0.0v 1379.45n 0.0v 1379.55n 0.0v 1389.45n 0.0v 1389.55n 0.0v 1399.45n 0.0v 1399.55n 0.0v 1409.45n 0.0v 1409.55n 0.0v 1419.45n 0.0v 1419.55n 0.0v 1429.45n 0.0v 1429.55n 0.0v 1439.45n 0.0v 1439.55n 0.0v 1449.45n 0.0v 1449.55n 0.0v 1459.45n 0.0v 1459.55n 0.0v 1469.45n 0.0v 1469.55n 0.0v 1479.45n 0.0v 1479.55n 0.0v 1489.45n 0.0v 1489.55n 0.0v 1499.45n 0.0v 1499.55n 0.0v 1509.45n 0.0v 1509.55n 0.0v 1519.45n 0.0v 1519.55n 0.0v 1529.45n 0.0v 1529.55n 0.0v 1539.45n 0.0v 1539.55n 0.0v 1549.45n 0.0v 1549.55n 0.0v 1559.45n 0.0v 1559.55n 0.0v 1569.45n 0.0v 1569.55n 0.0v 1579.45n 0.0v 1579.55n 0.0v 1589.45n 0.0v 1589.55n 0.0v 1599.45n 0.0v 1599.55n 0.0v 1609.45n 0.0v 1609.55n 0.0v 1619.45n 0.0v 1619.55n 0.0v 1629.45n 0.0v 1629.55n 0.0v 1639.45n 0.0v 1639.55n 0.0v 1649.45n 0.0v 1649.55n 0.0v 1659.45n 0.0v 1659.55n 0.0v 1669.45n 0.0v 1669.55n 0.0v 1679.45n 0.0v 1679.55n 0.0v 1689.45n 0.0v 1689.55n 0.0v 1699.45n 0.0v 1699.55n 0.0v 1709.45n 0.0v 1709.55n 0.0v 1719.45n 0.0v 1719.55n 0.0v 1729.45n 0.0v 1729.55n 0.0v 1739.45n 0.0v 1739.55n 0.0v 1749.45n 0.0v 1749.55n 0.0v 1759.45n 0.0v 1759.55n 0.0v 1769.45n 0.0v 1769.55n 0.0v 1779.45n 0.0v 1779.55n 0.0v 1789.45n 0.0v 1789.55n 0.0v 1799.45n 0.0v 1799.55n 0.0v 1809.45n 0.0v 1809.55n 0.0v 1819.45n 0.0v 1819.55n 0.0v 1829.45n 0.0v 1829.55n 0.0v 1839.45n 0.0v 1839.55n 0.0v 1849.45n 0.0v 1849.55n 0.0v 1859.45n 0.0v 1859.55n 0.0v 1869.45n 0.0v 1869.55n 0.0v 1879.45n 0.0v 1879.55n 0.0v 1889.45n 0.0v 1889.55n 0.0v 1899.45n 0.0v 1899.55n 0.0v 1909.45n 0.0v 1909.55n 0.0v 1919.45n 0.0v 1919.55n 0.0v 1929.45n 0.0v 1929.55n 0.0v 1939.45n 0.0v 1939.55n 0.0v 1949.45n 0.0v 1949.55n 0.0v 1959.45n 0.0v 1959.55n 0.0v 1969.45n 0.0v 1969.55n 0.0v 1979.45n 0.0v 1979.55n 0.0v 1989.45n 0.0v 1989.55n 0.0v 1999.45n 0.0v 1999.55n 0.0v 2009.45n 0.0v 2009.55n 0.0v 2019.45n 0.0v 2019.55n 0.0v 2029.45n 0.0v 2029.55n 0.0v 2039.45n 0.0v 2039.55n 0.0v 2049.45n 0.0v 2049.55n 0.0v )
* (time, data): [(0, 0), (10, 0), (20, 0), (30, 0), (40, 0), (50, 0), (60, 0), (70, 0), (80, 0), (90, 0), (100, 0), (110, 0), (120, 0), (130, 0), (140, 0), (150, 0), (160, 0), (170, 0), (180, 0), (190, 0), (200, 0), (210, 0), (220, 0), (230, 0), (240, 0), (250, 0), (260, 0), (270, 0), (280, 0), (290, 1), (300, 1), (310, 1), (320, 0), (330, 0), (340, 0), (350, 1), (360, 0), (370, 1), (380, 1), (390, 0), (400, 0), (410, 0), (420, 0), (430, 0), (440, 0), (450, 1), (460, 1), (470, 1), (480, 1), (490, 1), (500, 1), (510, 0), (520, 0), (530, 0), (540, 0), (550, 1), (560, 1), (570, 1), (580, 0), (590, 0), (600, 0), (610, 1), (620, 1), (630, 1), (640, 0), (650, 0), (660, 1), (670, 1), (680, 1), (690, 1), (700, 1), (710, 1), (720, 0), (730, 0), (740, 1), (750, 0), (760, 0), (770, 0), (780, 0), (790, 0), (800, 0), (810, 1), (820, 0), (830, 1), (840, 1), (850, 0), (860, 0), (870, 0), (880, 1), (890, 0), (900, 0), (910, 1), (920, 1), (930, 0), (940, 1), (950, 1), (960, 1), (970, 0), (980, 1), (990, 0), (1000, 1), (1010, 0), (1020, 1), (1030, 0), (1040, 0), (1050, 0), (1060, 1), (1070, 0), (1080, 0), (1090, 0), (1100, 1), (1110, 1), (1120, 1), (1130, 1), (1140, 0), (1150, 1), (1160, 0), (1170, 1), (1180, 0), (1190, 0), (1200, 0), (1210, 1), (1220, 0), (1230, 0), (1240, 1), (1250, 1), (1260, 1), (1270, 1), (1280, 0), (1290, 0), (1300, 0), (1310, 1), (1320, 0), (1330, 1), (1340, 1), (1350, 0), (1360, 1), (1370, 1), (1380, 1), (1390, 1), (1400, 1), (1410, 1), (1420, 1), (1430, 0), (1440, 1), (1450, 1), (1460, 1), (1470, 0), (1480, 1), (1490, 1), (1500, 1), (1510, 0), (1520, 1), (1530, 0), (1540, 0), (1550, 1), (1560, 1), (1570, 1), (1580, 1), (1590, 0), (1600, 1), (1610, 1), (1620, 1), (1630, 0), (1640, 0), (1650, 0), (1660, 0), (1670, 1), (1680, 1), (1690, 1), (1700, 0), (1710, 1), (1720, 1), (1730, 0), (1740, 1), (1750, 1), (1760, 1), (1770, 0), (1780, 0), (1790, 0), (1800, 1), (1810, 0), (1820, 0), (1830, 0), (1840, 0), (1850, 1), (1860, 1), (1870, 1), (1880, 0), (1890, 0), (1900, 0), (1910, 0), (1920, 0), (1930, 1), (1940, 1), (1950, 0), (1960, 0), (1970, 1), (1980, 1), (1990, 0), (2000, 0), (2010, 0), (2020, 1), (2030, 1), (2040, 1), (2050, 1)]
Va0_1  a0_1  0 PWL (0n 0.0v 9.45n 0.0v 9.55n 0.0v 19.45n 0.0v 19.55n 0.0v 29.45n 0.0v 29.55n 0.0v 39.45n 0.0v 39.55n 0.0v 49.45n 0.0v 49.55n 0.0v 59.45n 0.0v 59.55n 0.0v 69.45n 0.0v 69.55n 0.0v 79.45n 0.0v 79.55n 0.0v 89.45n 0.0v 89.55n 0.0v 99.45n 0.0v 99.55n 0.0v 109.45n 0.0v 109.55n 0.0v 119.45n 0.0v 119.55n 0.0v 129.45n 0.0v 129.55n 0.0v 139.45n 0.0v 139.55n 0.0v 149.45n 0.0v 149.55n 0.0v 159.45n 0.0v 159.55n 0.0v 169.45n 0.0v 169.55n 0.0v 179.45n 0.0v 179.55n 0.0v 189.45n 0.0v 189.55n 0.0v 199.45n 0.0v 199.55n 0.0v 209.45n 0.0v 209.55n 0.0v 219.45n 0.0v 219.55n 0.0v 229.45n 0.0v 229.55n 0.0v 239.45n 0.0v 239.55n 0.0v 249.45n 0.0v 249.55n 0.0v 259.45n 0.0v 259.55n 0.0v 269.45n 0.0v 269.55n 0.0v 279.45n 0.0v 279.55n 0.0v 289.45n 0.0v 289.55n 5.0v 299.45n 5.0v 299.55n 5.0v 309.45n 5.0v 309.55n 5.0v 319.45n 5.0v 319.55n 0.0v 329.45n 0.0v 329.55n 0.0v 339.45n 0.0v 339.55n 0.0v 349.45n 0.0v 349.55n 5.0v 359.45n 5.0v 359.55n 0.0v 369.45n 0.0v 369.55n 5.0v 379.45n 5.0v 379.55n 5.0v 389.45n 5.0v 389.55n 0.0v 399.45n 0.0v 399.55n 0.0v 409.45n 0.0v 409.55n 0.0v 419.45n 0.0v 419.55n 0.0v 429.45n 0.0v 429.55n 0.0v 439.45n 0.0v 439.55n 0.0v 449.45n 0.0v 449.55n 5.0v 459.45n 5.0v 459.55n 5.0v 469.45n 5.0v 469.55n 5.0v 479.45n 5.0v 479.55n 5.0v 489.45n 5.0v 489.55n 5.0v 499.45n 5.0v 499.55n 5.0v 509.45n 5.0v 509.55n 0.0v 519.45n 0.0v 519.55n 0.0v 529.45n 0.0v 529.55n 0.0v 539.45n 0.0v 539.55n 0.0v 549.45n 0.0v 549.55n 5.0v 559.45n 5.0v 559.55n 5.0v 569.45n 5.0v 569.55n 5.0v 579.45n 5.0v 579.55n 0.0v 589.45n 0.0v 589.55n 0.0v 599.45n 0.0v 599.55n 0.0v 609.45n 0.0v 609.55n 5.0v 619.45n 5.0v 619.55n 5.0v 629.45n 5.0v 629.55n 5.0v 639.45n 5.0v 639.55n 0.0v 649.45n 0.0v 649.55n 0.0v 659.45n 0.0v 659.55n 5.0v 669.45n 5.0v 669.55n 5.0v 679.45n 5.0v 679.55n 5.0v 689.45n 5.0v 689.55n 5.0v 699.45n 5.0v 699.55n 5.0v 709.45n 5.0v 709.55n 5.0v 719.45n 5.0v 719.55n 0.0v 729.45n 0.0v 729.55n 0.0v 739.45n 0.0v 739.55n 5.0v 749.45n 5.0v 749.55n 0.0v 759.45n 0.0v 759.55n 0.0v 769.45n 0.0v 769.55n 0.0v 779.45n 0.0v 779.55n 0.0v 789.45n 0.0v 789.55n 0.0v 799.45n 0.0v 799.55n 0.0v 809.45n 0.0v 809.55n 5.0v 819.45n 5.0v 819.55n 0.0v 829.45n 0.0v 829.55n 5.0v 839.45n 5.0v 839.55n 5.0v 849.45n 5.0v 849.55n 0.0v 859.45n 0.0v 859.55n 0.0v 869.45n 0.0v 869.55n 0.0v 879.45n 0.0v 879.55n 5.0v 889.45n 5.0v 889.55n 0.0v 899.45n 0.0v 899.55n 0.0v 909.45n 0.0v 909.55n 5.0v 919.45n 5.0v 919.55n 5.0v 929.45n 5.0v 929.55n 0.0v 939.45n 0.0v 939.55n 5.0v 949.45n 5.0v 949.55n 5.0v 959.45n 5.0v 959.55n 5.0v 969.45n 5.0v 969.55n 0.0v 979.45n 0.0v 979.55n 5.0v 989.45n 5.0v 989.55n 0.0v 999.45n 0.0v 999.55n 5.0v 1009.45n 5.0v 1009.55n 0.0v 1019.45n 0.0v 1019.55n 5.0v 1029.45n 5.0v 1029.55n 0.0v 1039.45n 0.0v 1039.55n 0.0v 1049.45n 0.0v 1049.55n 0.0v 1059.45n 0.0v 1059.55n 5.0v 1069.45n 5.0v 1069.55n 0.0v 1079.45n 0.0v 1079.55n 0.0v 1089.45n 0.0v 1089.55n 0.0v 1099.45n 0.0v 1099.55n 5.0v 1109.45n 5.0v 1109.55n 5.0v 1119.45n 5.0v 1119.55n 5.0v 1129.45n 5.0v 1129.55n 5.0v 1139.45n 5.0v 1139.55n 0.0v 1149.45n 0.0v 1149.55n 5.0v 1159.45n 5.0v 1159.55n 0.0v 1169.45n 0.0v 1169.55n 5.0v 1179.45n 5.0v 1179.55n 0.0v 1189.45n 0.0v 1189.55n 0.0v 1199.45n 0.0v 1199.55n 0.0v 1209.45n 0.0v 1209.55n 5.0v 1219.45n 5.0v 1219.55n 0.0v 1229.45n 0.0v 1229.55n 0.0v 1239.45n 0.0v 1239.55n 5.0v 1249.45n 5.0v 1249.55n 5.0v 1259.45n 5.0v 1259.55n 5.0v 1269.45n 5.0v 1269.55n 5.0v 1279.45n 5.0v 1279.55n 0.0v 1289.45n 0.0v 1289.55n 0.0v 1299.45n 0.0v 1299.55n 0.0v 1309.45n 0.0v 1309.55n 5.0v 1319.45n 5.0v 1319.55n 0.0v 1329.45n 0.0v 1329.55n 5.0v 1339.45n 5.0v 1339.55n 5.0v 1349.45n 5.0v 1349.55n 0.0v 1359.45n 0.0v 1359.55n 5.0v 1369.45n 5.0v 1369.55n 5.0v 1379.45n 5.0v 1379.55n 5.0v 1389.45n 5.0v 1389.55n 5.0v 1399.45n 5.0v 1399.55n 5.0v 1409.45n 5.0v 1409.55n 5.0v 1419.45n 5.0v 1419.55n 5.0v 1429.45n 5.0v 1429.55n 0.0v 1439.45n 0.0v 1439.55n 5.0v 1449.45n 5.0v 1449.55n 5.0v 1459.45n 5.0v 1459.55n 5.0v 1469.45n 5.0v 1469.55n 0.0v 1479.45n 0.0v 1479.55n 5.0v 1489.45n 5.0v 1489.55n 5.0v 1499.45n 5.0v 1499.55n 5.0v 1509.45n 5.0v 1509.55n 0.0v 1519.45n 0.0v 1519.55n 5.0v 1529.45n 5.0v 1529.55n 0.0v 1539.45n 0.0v 1539.55n 0.0v 1549.45n 0.0v 1549.55n 5.0v 1559.45n 5.0v 1559.55n 5.0v 1569.45n 5.0v 1569.55n 5.0v 1579.45n 5.0v 1579.55n 5.0v 1589.45n 5.0v 1589.55n 0.0v 1599.45n 0.0v 1599.55n 5.0v 1609.45n 5.0v 1609.55n 5.0v 1619.45n 5.0v 1619.55n 5.0v 1629.45n 5.0v 1629.55n 0.0v 1639.45n 0.0v 1639.55n 0.0v 1649.45n 0.0v 1649.55n 0.0v 1659.45n 0.0v 1659.55n 0.0v 1669.45n 0.0v 1669.55n 5.0v 1679.45n 5.0v 1679.55n 5.0v 1689.45n 5.0v 1689.55n 5.0v 1699.45n 5.0v 1699.55n 0.0v 1709.45n 0.0v 1709.55n 5.0v 1719.45n 5.0v 1719.55n 5.0v 1729.45n 5.0v 1729.55n 0.0v 1739.45n 0.0v 1739.55n 5.0v 1749.45n 5.0v 1749.55n 5.0v 1759.45n 5.0v 1759.55n 5.0v 1769.45n 5.0v 1769.55n 0.0v 1779.45n 0.0v 1779.55n 0.0v 1789.45n 0.0v 1789.55n 0.0v 1799.45n 0.0v 1799.55n 5.0v 1809.45n 5.0v 1809.55n 0.0v 1819.45n 0.0v 1819.55n 0.0v 1829.45n 0.0v 1829.55n 0.0v 1839.45n 0.0v 1839.55n 0.0v 1849.45n 0.0v 1849.55n 5.0v 1859.45n 5.0v 1859.55n 5.0v 1869.45n 5.0v 1869.55n 5.0v 1879.45n 5.0v 1879.55n 0.0v 1889.45n 0.0v 1889.55n 0.0v 1899.45n 0.0v 1899.55n 0.0v 1909.45n 0.0v 1909.55n 0.0v 1919.45n 0.0v 1919.55n 0.0v 1929.45n 0.0v 1929.55n 5.0v 1939.45n 5.0v 1939.55n 5.0v 1949.45n 5.0v 1949.55n 0.0v 1959.45n 0.0v 1959.55n 0.0v 1969.45n 0.0v 1969.55n 5.0v 1979.45n 5.0v 1979.55n 5.0v 1989.45n 5.0v 1989.55n 0.0v 1999.45n 0.0v 1999.55n 0.0v 2009.45n 0.0v 2009.55n 0.0v 2019.45n 0.0v 2019.55n 5.0v 2029.45n 5.0v 2029.55n 5.0v 2039.45n 5.0v 2039.55n 5.0v 2049.45n 5.0v 2049.55n 5.0v )
* (time, data): [(0, 0), (10, 0), (20, 0), (30, 0), (40, 0), (50, 0), (60, 0), (70, 0), (80, 0), (90, 0), (100, 0), (110, 0), (120, 0), (130, 0), (140, 0), (150, 0), (160, 0), (170, 0), (180, 0), (190, 0), (200, 0), (210, 0), (220, 0), (230, 0), (240, 0), (250, 0), (260, 0), (270, 0), (280, 0), (290, 1), (300, 1), (310, 1), (320, 0), (330, 0), (340, 0), (350, 1), (360, 0), (370, 1), (380, 1), (390, 0), (400, 0), (410, 0), (420, 0), (430, 0), (440, 0), (450, 1), (460, 1), (470, 1), (480, 1), (490, 1), (500, 1), (510, 0), (520, 0), (530, 0), (540, 0), (550, 1), (560, 1), (570, 1), (580, 0), (590, 0), (600, 0), (610, 1), (620, 1), (630, 1), (640, 0), (650, 0), (660, 1), (670, 1), (680, 1), (690, 1), (700, 1), (710, 1), (720, 0), (730, 0), (740, 1), (750, 0), (760, 0), (770, 0), (780, 0), (790, 0), (800, 0), (810, 1), (820, 0), (830, 1), (840, 1), (850, 0), (860, 0), (870, 0), (880, 1), (890, 0), (900, 0), (910, 1), (920, 1), (930, 0), (940, 1), (950, 1), (960, 1), (970, 0), (980, 1), (990, 0), (1000, 1), (1010, 0), (1020, 1), (1030, 0), (1040, 0), (1050, 0), (1060, 1), (1070, 0), (1080, 0), (1090, 0), (1100, 1), (1110, 1), (1120, 1), (1130, 1), (1140, 0), (1150, 1), (1160, 0), (1170, 1), (1180, 0), (1190, 0), (1200, 0), (1210, 1), (1220, 0), (1230, 0), (1240, 1), (1250, 1), (1260, 1), (1270, 1), (1280, 0), (1290, 0), (1300, 0), (1310, 1), (1320, 0), (1330, 1), (1340, 1), (1350, 0), (1360, 1), (1370, 1), (1380, 1), (1390, 1), (1400, 1), (1410, 1), (1420, 1), (1430, 0), (1440, 1), (1450, 1), (1460, 1), (1470, 0), (1480, 1), (1490, 1), (1500, 1), (1510, 0), (1520, 1), (1530, 0), (1540, 0), (1550, 1), (1560, 1), (1570, 1), (1580, 1), (1590, 0), (1600, 1), (1610, 1), (1620, 1), (1630, 0), (1640, 0), (1650, 0), (1660, 0), (1670, 1), (1680, 1), (1690, 1), (1700, 0), (1710, 1), (1720, 1), (1730, 0), (1740, 1), (1750, 1), (1760, 1), (1770, 0), (1780, 0), (1790, 0), (1800, 1), (1810, 0), (1820, 0), (1830, 0), (1840, 0), (1850, 1), (1860, 1), (1870, 1), (1880, 0), (1890, 0), (1900, 0), (1910, 0), (1920, 0), (1930, 1), (1940, 1), (1950, 0), (1960, 0), (1970, 1), (1980, 1), (1990, 0), (2000, 0), (2010, 0), (2020, 1), (2030, 1), (2040, 1), (2050, 1)]
Va0_2  a0_2  0 PWL (0n 0.0v 9.45n 0.0v 9.55n 0.0v 19.45n 0.0v 19.55n 0.0v 29.45n 0.0v 29.55n 0.0v 39.45n 0.0v 39.55n 0.0v 49.45n 0.0v 49.55n 0.0v 59.45n 0.0v 59.55n 0.0v 69.45n 0.0v 69.55n 0.0v 79.45n 0.0v 79.55n 0.0v 89.45n 0.0v 89.55n 0.0v 99.45n 0.0v 99.55n 0.0v 109.45n 0.0v 109.55n 0.0v 119.45n 0.0v 119.55n 0.0v 129.45n 0.0v 129.55n 0.0v 139.45n 0.0v 139.55n 0.0v 149.45n 0.0v 149.55n 0.0v 159.45n 0.0v 159.55n 0.0v 169.45n 0.0v 169.55n 0.0v 179.45n 0.0v 179.55n 0.0v 189.45n 0.0v 189.55n 0.0v 199.45n 0.0v 199.55n 0.0v 209.45n 0.0v 209.55n 0.0v 219.45n 0.0v 219.55n 0.0v 229.45n 0.0v 229.55n 0.0v 239.45n 0.0v 239.55n 0.0v 249.45n 0.0v 249.55n 0.0v 259.45n 0.0v 259.55n 0.0v 269.45n 0.0v 269.55n 0.0v 279.45n 0.0v 279.55n 0.0v 289.45n 0.0v 289.55n 5.0v 299.45n 5.0v 299.55n 5.0v 309.45n 5.0v 309.55n 5.0v 319.45n 5.0v 319.55n 0.0v 329.45n 0.0v 329.55n 0.0v 339.45n 0.0v 339.55n 0.0v 349.45n 0.0v 349.55n 5.0v 359.45n 5.0v 359.55n 0.0v 369.45n 0.0v 369.55n 5.0v 379.45n 5.0v 379.55n 5.0v 389.45n 5.0v 389.55n 0.0v 399.45n 0.0v 399.55n 0.0v 409.45n 0.0v 409.55n 0.0v 419.45n 0.0v 419.55n 0.0v 429.45n 0.0v 429.55n 0.0v 439.45n 0.0v 439.55n 0.0v 449.45n 0.0v 449.55n 5.0v 459.45n 5.0v 459.55n 5.0v 469.45n 5.0v 469.55n 5.0v 479.45n 5.0v 479.55n 5.0v 489.45n 5.0v 489.55n 5.0v 499.45n 5.0v 499.55n 5.0v 509.45n 5.0v 509.55n 0.0v 519.45n 0.0v 519.55n 0.0v 529.45n 0.0v 529.55n 0.0v 539.45n 0.0v 539.55n 0.0v 549.45n 0.0v 549.55n 5.0v 559.45n 5.0v 559.55n 5.0v 569.45n 5.0v 569.55n 5.0v 579.45n 5.0v 579.55n 0.0v 589.45n 0.0v 589.55n 0.0v 599.45n 0.0v 599.55n 0.0v 609.45n 0.0v 609.55n 5.0v 619.45n 5.0v 619.55n 5.0v 629.45n 5.0v 629.55n 5.0v 639.45n 5.0v 639.55n 0.0v 649.45n 0.0v 649.55n 0.0v 659.45n 0.0v 659.55n 5.0v 669.45n 5.0v 669.55n 5.0v 679.45n 5.0v 679.55n 5.0v 689.45n 5.0v 689.55n 5.0v 699.45n 5.0v 699.55n 5.0v 709.45n 5.0v 709.55n 5.0v 719.45n 5.0v 719.55n 0.0v 729.45n 0.0v 729.55n 0.0v 739.45n 0.0v 739.55n 5.0v 749.45n 5.0v 749.55n 0.0v 759.45n 0.0v 759.55n 0.0v 769.45n 0.0v 769.55n 0.0v 779.45n 0.0v 779.55n 0.0v 789.45n 0.0v 789.55n 0.0v 799.45n 0.0v 799.55n 0.0v 809.45n 0.0v 809.55n 5.0v 819.45n 5.0v 819.55n 0.0v 829.45n 0.0v 829.55n 5.0v 839.45n 5.0v 839.55n 5.0v 849.45n 5.0v 849.55n 0.0v 859.45n 0.0v 859.55n 0.0v 869.45n 0.0v 869.55n 0.0v 879.45n 0.0v 879.55n 5.0v 889.45n 5.0v 889.55n 0.0v 899.45n 0.0v 899.55n 0.0v 909.45n 0.0v 909.55n 5.0v 919.45n 5.0v 919.55n 5.0v 929.45n 5.0v 929.55n 0.0v 939.45n 0.0v 939.55n 5.0v 949.45n 5.0v 949.55n 5.0v 959.45n 5.0v 959.55n 5.0v 969.45n 5.0v 969.55n 0.0v 979.45n 0.0v 979.55n 5.0v 989.45n 5.0v 989.55n 0.0v 999.45n 0.0v 999.55n 5.0v 1009.45n 5.0v 1009.55n 0.0v 1019.45n 0.0v 1019.55n 5.0v 1029.45n 5.0v 1029.55n 0.0v 1039.45n 0.0v 1039.55n 0.0v 1049.45n 0.0v 1049.55n 0.0v 1059.45n 0.0v 1059.55n 5.0v 1069.45n 5.0v 1069.55n 0.0v 1079.45n 0.0v 1079.55n 0.0v 1089.45n 0.0v 1089.55n 0.0v 1099.45n 0.0v 1099.55n 5.0v 1109.45n 5.0v 1109.55n 5.0v 1119.45n 5.0v 1119.55n 5.0v 1129.45n 5.0v 1129.55n 5.0v 1139.45n 5.0v 1139.55n 0.0v 1149.45n 0.0v 1149.55n 5.0v 1159.45n 5.0v 1159.55n 0.0v 1169.45n 0.0v 1169.55n 5.0v 1179.45n 5.0v 1179.55n 0.0v 1189.45n 0.0v 1189.55n 0.0v 1199.45n 0.0v 1199.55n 0.0v 1209.45n 0.0v 1209.55n 5.0v 1219.45n 5.0v 1219.55n 0.0v 1229.45n 0.0v 1229.55n 0.0v 1239.45n 0.0v 1239.55n 5.0v 1249.45n 5.0v 1249.55n 5.0v 1259.45n 5.0v 1259.55n 5.0v 1269.45n 5.0v 1269.55n 5.0v 1279.45n 5.0v 1279.55n 0.0v 1289.45n 0.0v 1289.55n 0.0v 1299.45n 0.0v 1299.55n 0.0v 1309.45n 0.0v 1309.55n 5.0v 1319.45n 5.0v 1319.55n 0.0v 1329.45n 0.0v 1329.55n 5.0v 1339.45n 5.0v 1339.55n 5.0v 1349.45n 5.0v 1349.55n 0.0v 1359.45n 0.0v 1359.55n 5.0v 1369.45n 5.0v 1369.55n 5.0v 1379.45n 5.0v 1379.55n 5.0v 1389.45n 5.0v 1389.55n 5.0v 1399.45n 5.0v 1399.55n 5.0v 1409.45n 5.0v 1409.55n 5.0v 1419.45n 5.0v 1419.55n 5.0v 1429.45n 5.0v 1429.55n 0.0v 1439.45n 0.0v 1439.55n 5.0v 1449.45n 5.0v 1449.55n 5.0v 1459.45n 5.0v 1459.55n 5.0v 1469.45n 5.0v 1469.55n 0.0v 1479.45n 0.0v 1479.55n 5.0v 1489.45n 5.0v 1489.55n 5.0v 1499.45n 5.0v 1499.55n 5.0v 1509.45n 5.0v 1509.55n 0.0v 1519.45n 0.0v 1519.55n 5.0v 1529.45n 5.0v 1529.55n 0.0v 1539.45n 0.0v 1539.55n 0.0v 1549.45n 0.0v 1549.55n 5.0v 1559.45n 5.0v 1559.55n 5.0v 1569.45n 5.0v 1569.55n 5.0v 1579.45n 5.0v 1579.55n 5.0v 1589.45n 5.0v 1589.55n 0.0v 1599.45n 0.0v 1599.55n 5.0v 1609.45n 5.0v 1609.55n 5.0v 1619.45n 5.0v 1619.55n 5.0v 1629.45n 5.0v 1629.55n 0.0v 1639.45n 0.0v 1639.55n 0.0v 1649.45n 0.0v 1649.55n 0.0v 1659.45n 0.0v 1659.55n 0.0v 1669.45n 0.0v 1669.55n 5.0v 1679.45n 5.0v 1679.55n 5.0v 1689.45n 5.0v 1689.55n 5.0v 1699.45n 5.0v 1699.55n 0.0v 1709.45n 0.0v 1709.55n 5.0v 1719.45n 5.0v 1719.55n 5.0v 1729.45n 5.0v 1729.55n 0.0v 1739.45n 0.0v 1739.55n 5.0v 1749.45n 5.0v 1749.55n 5.0v 1759.45n 5.0v 1759.55n 5.0v 1769.45n 5.0v 1769.55n 0.0v 1779.45n 0.0v 1779.55n 0.0v 1789.45n 0.0v 1789.55n 0.0v 1799.45n 0.0v 1799.55n 5.0v 1809.45n 5.0v 1809.55n 0.0v 1819.45n 0.0v 1819.55n 0.0v 1829.45n 0.0v 1829.55n 0.0v 1839.45n 0.0v 1839.55n 0.0v 1849.45n 0.0v 1849.55n 5.0v 1859.45n 5.0v 1859.55n 5.0v 1869.45n 5.0v 1869.55n 5.0v 1879.45n 5.0v 1879.55n 0.0v 1889.45n 0.0v 1889.55n 0.0v 1899.45n 0.0v 1899.55n 0.0v 1909.45n 0.0v 1909.55n 0.0v 1919.45n 0.0v 1919.55n 0.0v 1929.45n 0.0v 1929.55n 5.0v 1939.45n 5.0v 1939.55n 5.0v 1949.45n 5.0v 1949.55n 0.0v 1959.45n 0.0v 1959.55n 0.0v 1969.45n 0.0v 1969.55n 5.0v 1979.45n 5.0v 1979.55n 5.0v 1989.45n 5.0v 1989.55n 0.0v 1999.45n 0.0v 1999.55n 0.0v 2009.45n 0.0v 2009.55n 0.0v 2019.45n 0.0v 2019.55n 5.0v 2029.45n 5.0v 2029.55n 5.0v 2039.45n 5.0v 2039.55n 5.0v 2049.45n 5.0v 2049.55n 5.0v )
* (time, data): [(0, 0), (10, 0), (20, 0), (30, 0), (40, 0), (50, 0), (60, 0), (70, 0), (80, 0), (90, 0), (100, 0), (110, 0), (120, 0), (130, 0), (140, 0), (150, 0), (160, 0), (170, 0), (180, 0), (190, 0), (200, 0), (210, 0), (220, 0), (230, 0), (240, 0), (250, 0), (260, 0), (270, 0), (280, 0), (290, 1), (300, 1), (310, 1), (320, 0), (330, 0), (340, 0), (350, 1), (360, 0), (370, 1), (380, 1), (390, 0), (400, 0), (410, 0), (420, 0), (430, 0), (440, 0), (450, 1), (460, 1), (470, 1), (480, 1), (490, 1), (500, 1), (510, 0), (520, 0), (530, 0), (540, 0), (550, 1), (560, 1), (570, 1), (580, 0), (590, 0), (600, 0), (610, 1), (620, 1), (630, 1), (640, 0), (650, 0), (660, 1), (670, 1), (680, 1), (690, 1), (700, 1), (710, 1), (720, 0), (730, 0), (740, 1), (750, 0), (760, 0), (770, 0), (780, 0), (790, 0), (800, 0), (810, 1), (820, 0), (830, 1), (840, 1), (850, 0), (860, 0), (870, 0), (880, 1), (890, 0), (900, 0), (910, 1), (920, 1), (930, 0), (940, 1), (950, 1), (960, 1), (970, 0), (980, 1), (990, 0), (1000, 1), (1010, 0), (1020, 1), (1030, 0), (1040, 0), (1050, 0), (1060, 1), (1070, 0), (1080, 0), (1090, 0), (1100, 1), (1110, 1), (1120, 1), (1130, 1), (1140, 0), (1150, 1), (1160, 0), (1170, 1), (1180, 0), (1190, 0), (1200, 0), (1210, 1), (1220, 0), (1230, 0), (1240, 1), (1250, 1), (1260, 1), (1270, 1), (1280, 0), (1290, 0), (1300, 0), (1310, 1), (1320, 0), (1330, 1), (1340, 1), (1350, 0), (1360, 1), (1370, 1), (1380, 1), (1390, 1), (1400, 1), (1410, 1), (1420, 1), (1430, 0), (1440, 1), (1450, 1), (1460, 1), (1470, 0), (1480, 1), (1490, 1), (1500, 1), (1510, 0), (1520, 1), (1530, 0), (1540, 0), (1550, 1), (1560, 1), (1570, 1), (1580, 1), (1590, 0), (1600, 1), (1610, 1), (1620, 1), (1630, 0), (1640, 0), (1650, 0), (1660, 0), (1670, 1), (1680, 1), (1690, 1), (1700, 0), (1710, 1), (1720, 1), (1730, 0), (1740, 1), (1750, 1), (1760, 1), (1770, 0), (1780, 0), (1790, 0), (1800, 1), (1810, 0), (1820, 0), (1830, 0), (1840, 0), (1850, 1), (1860, 1), (1870, 1), (1880, 0), (1890, 0), (1900, 0), (1910, 0), (1920, 0), (1930, 1), (1940, 1), (1950, 0), (1960, 0), (1970, 1), (1980, 1), (1990, 0), (2000, 0), (2010, 0), (2020, 1), (2030, 1), (2040, 1), (2050, 1)]
Va0_3  a0_3  0 PWL (0n 0.0v 9.45n 0.0v 9.55n 0.0v 19.45n 0.0v 19.55n 0.0v 29.45n 0.0v 29.55n 0.0v 39.45n 0.0v 39.55n 0.0v 49.45n 0.0v 49.55n 0.0v 59.45n 0.0v 59.55n 0.0v 69.45n 0.0v 69.55n 0.0v 79.45n 0.0v 79.55n 0.0v 89.45n 0.0v 89.55n 0.0v 99.45n 0.0v 99.55n 0.0v 109.45n 0.0v 109.55n 0.0v 119.45n 0.0v 119.55n 0.0v 129.45n 0.0v 129.55n 0.0v 139.45n 0.0v 139.55n 0.0v 149.45n 0.0v 149.55n 0.0v 159.45n 0.0v 159.55n 0.0v 169.45n 0.0v 169.55n 0.0v 179.45n 0.0v 179.55n 0.0v 189.45n 0.0v 189.55n 0.0v 199.45n 0.0v 199.55n 0.0v 209.45n 0.0v 209.55n 0.0v 219.45n 0.0v 219.55n 0.0v 229.45n 0.0v 229.55n 0.0v 239.45n 0.0v 239.55n 0.0v 249.45n 0.0v 249.55n 0.0v 259.45n 0.0v 259.55n 0.0v 269.45n 0.0v 269.55n 0.0v 279.45n 0.0v 279.55n 0.0v 289.45n 0.0v 289.55n 5.0v 299.45n 5.0v 299.55n 5.0v 309.45n 5.0v 309.55n 5.0v 319.45n 5.0v 319.55n 0.0v 329.45n 0.0v 329.55n 0.0v 339.45n 0.0v 339.55n 0.0v 349.45n 0.0v 349.55n 5.0v 359.45n 5.0v 359.55n 0.0v 369.45n 0.0v 369.55n 5.0v 379.45n 5.0v 379.55n 5.0v 389.45n 5.0v 389.55n 0.0v 399.45n 0.0v 399.55n 0.0v 409.45n 0.0v 409.55n 0.0v 419.45n 0.0v 419.55n 0.0v 429.45n 0.0v 429.55n 0.0v 439.45n 0.0v 439.55n 0.0v 449.45n 0.0v 449.55n 5.0v 459.45n 5.0v 459.55n 5.0v 469.45n 5.0v 469.55n 5.0v 479.45n 5.0v 479.55n 5.0v 489.45n 5.0v 489.55n 5.0v 499.45n 5.0v 499.55n 5.0v 509.45n 5.0v 509.55n 0.0v 519.45n 0.0v 519.55n 0.0v 529.45n 0.0v 529.55n 0.0v 539.45n 0.0v 539.55n 0.0v 549.45n 0.0v 549.55n 5.0v 559.45n 5.0v 559.55n 5.0v 569.45n 5.0v 569.55n 5.0v 579.45n 5.0v 579.55n 0.0v 589.45n 0.0v 589.55n 0.0v 599.45n 0.0v 599.55n 0.0v 609.45n 0.0v 609.55n 5.0v 619.45n 5.0v 619.55n 5.0v 629.45n 5.0v 629.55n 5.0v 639.45n 5.0v 639.55n 0.0v 649.45n 0.0v 649.55n 0.0v 659.45n 0.0v 659.55n 5.0v 669.45n 5.0v 669.55n 5.0v 679.45n 5.0v 679.55n 5.0v 689.45n 5.0v 689.55n 5.0v 699.45n 5.0v 699.55n 5.0v 709.45n 5.0v 709.55n 5.0v 719.45n 5.0v 719.55n 0.0v 729.45n 0.0v 729.55n 0.0v 739.45n 0.0v 739.55n 5.0v 749.45n 5.0v 749.55n 0.0v 759.45n 0.0v 759.55n 0.0v 769.45n 0.0v 769.55n 0.0v 779.45n 0.0v 779.55n 0.0v 789.45n 0.0v 789.55n 0.0v 799.45n 0.0v 799.55n 0.0v 809.45n 0.0v 809.55n 5.0v 819.45n 5.0v 819.55n 0.0v 829.45n 0.0v 829.55n 5.0v 839.45n 5.0v 839.55n 5.0v 849.45n 5.0v 849.55n 0.0v 859.45n 0.0v 859.55n 0.0v 869.45n 0.0v 869.55n 0.0v 879.45n 0.0v 879.55n 5.0v 889.45n 5.0v 889.55n 0.0v 899.45n 0.0v 899.55n 0.0v 909.45n 0.0v 909.55n 5.0v 919.45n 5.0v 919.55n 5.0v 929.45n 5.0v 929.55n 0.0v 939.45n 0.0v 939.55n 5.0v 949.45n 5.0v 949.55n 5.0v 959.45n 5.0v 959.55n 5.0v 969.45n 5.0v 969.55n 0.0v 979.45n 0.0v 979.55n 5.0v 989.45n 5.0v 989.55n 0.0v 999.45n 0.0v 999.55n 5.0v 1009.45n 5.0v 1009.55n 0.0v 1019.45n 0.0v 1019.55n 5.0v 1029.45n 5.0v 1029.55n 0.0v 1039.45n 0.0v 1039.55n 0.0v 1049.45n 0.0v 1049.55n 0.0v 1059.45n 0.0v 1059.55n 5.0v 1069.45n 5.0v 1069.55n 0.0v 1079.45n 0.0v 1079.55n 0.0v 1089.45n 0.0v 1089.55n 0.0v 1099.45n 0.0v 1099.55n 5.0v 1109.45n 5.0v 1109.55n 5.0v 1119.45n 5.0v 1119.55n 5.0v 1129.45n 5.0v 1129.55n 5.0v 1139.45n 5.0v 1139.55n 0.0v 1149.45n 0.0v 1149.55n 5.0v 1159.45n 5.0v 1159.55n 0.0v 1169.45n 0.0v 1169.55n 5.0v 1179.45n 5.0v 1179.55n 0.0v 1189.45n 0.0v 1189.55n 0.0v 1199.45n 0.0v 1199.55n 0.0v 1209.45n 0.0v 1209.55n 5.0v 1219.45n 5.0v 1219.55n 0.0v 1229.45n 0.0v 1229.55n 0.0v 1239.45n 0.0v 1239.55n 5.0v 1249.45n 5.0v 1249.55n 5.0v 1259.45n 5.0v 1259.55n 5.0v 1269.45n 5.0v 1269.55n 5.0v 1279.45n 5.0v 1279.55n 0.0v 1289.45n 0.0v 1289.55n 0.0v 1299.45n 0.0v 1299.55n 0.0v 1309.45n 0.0v 1309.55n 5.0v 1319.45n 5.0v 1319.55n 0.0v 1329.45n 0.0v 1329.55n 5.0v 1339.45n 5.0v 1339.55n 5.0v 1349.45n 5.0v 1349.55n 0.0v 1359.45n 0.0v 1359.55n 5.0v 1369.45n 5.0v 1369.55n 5.0v 1379.45n 5.0v 1379.55n 5.0v 1389.45n 5.0v 1389.55n 5.0v 1399.45n 5.0v 1399.55n 5.0v 1409.45n 5.0v 1409.55n 5.0v 1419.45n 5.0v 1419.55n 5.0v 1429.45n 5.0v 1429.55n 0.0v 1439.45n 0.0v 1439.55n 5.0v 1449.45n 5.0v 1449.55n 5.0v 1459.45n 5.0v 1459.55n 5.0v 1469.45n 5.0v 1469.55n 0.0v 1479.45n 0.0v 1479.55n 5.0v 1489.45n 5.0v 1489.55n 5.0v 1499.45n 5.0v 1499.55n 5.0v 1509.45n 5.0v 1509.55n 0.0v 1519.45n 0.0v 1519.55n 5.0v 1529.45n 5.0v 1529.55n 0.0v 1539.45n 0.0v 1539.55n 0.0v 1549.45n 0.0v 1549.55n 5.0v 1559.45n 5.0v 1559.55n 5.0v 1569.45n 5.0v 1569.55n 5.0v 1579.45n 5.0v 1579.55n 5.0v 1589.45n 5.0v 1589.55n 0.0v 1599.45n 0.0v 1599.55n 5.0v 1609.45n 5.0v 1609.55n 5.0v 1619.45n 5.0v 1619.55n 5.0v 1629.45n 5.0v 1629.55n 0.0v 1639.45n 0.0v 1639.55n 0.0v 1649.45n 0.0v 1649.55n 0.0v 1659.45n 0.0v 1659.55n 0.0v 1669.45n 0.0v 1669.55n 5.0v 1679.45n 5.0v 1679.55n 5.0v 1689.45n 5.0v 1689.55n 5.0v 1699.45n 5.0v 1699.55n 0.0v 1709.45n 0.0v 1709.55n 5.0v 1719.45n 5.0v 1719.55n 5.0v 1729.45n 5.0v 1729.55n 0.0v 1739.45n 0.0v 1739.55n 5.0v 1749.45n 5.0v 1749.55n 5.0v 1759.45n 5.0v 1759.55n 5.0v 1769.45n 5.0v 1769.55n 0.0v 1779.45n 0.0v 1779.55n 0.0v 1789.45n 0.0v 1789.55n 0.0v 1799.45n 0.0v 1799.55n 5.0v 1809.45n 5.0v 1809.55n 0.0v 1819.45n 0.0v 1819.55n 0.0v 1829.45n 0.0v 1829.55n 0.0v 1839.45n 0.0v 1839.55n 0.0v 1849.45n 0.0v 1849.55n 5.0v 1859.45n 5.0v 1859.55n 5.0v 1869.45n 5.0v 1869.55n 5.0v 1879.45n 5.0v 1879.55n 0.0v 1889.45n 0.0v 1889.55n 0.0v 1899.45n 0.0v 1899.55n 0.0v 1909.45n 0.0v 1909.55n 0.0v 1919.45n 0.0v 1919.55n 0.0v 1929.45n 0.0v 1929.55n 5.0v 1939.45n 5.0v 1939.55n 5.0v 1949.45n 5.0v 1949.55n 0.0v 1959.45n 0.0v 1959.55n 0.0v 1969.45n 0.0v 1969.55n 5.0v 1979.45n 5.0v 1979.55n 5.0v 1989.45n 5.0v 1989.55n 0.0v 1999.45n 0.0v 1999.55n 0.0v 2009.45n 0.0v 2009.55n 0.0v 2019.45n 0.0v 2019.55n 5.0v 2029.45n 5.0v 2029.55n 5.0v 2039.45n 5.0v 2039.55n 5.0v 2049.45n 5.0v 2049.55n 5.0v )

 * Generation of control signals
* (time, data): [(0, 1), (10, 0), (20, 0), (30, 0), (40, 0), (50, 0), (60, 0), (70, 0), (80, 1), (90, 1), (100, 0), (110, 1), (120, 0), (130, 0), (140, 1), (150, 1), (160, 1), (170, 0), (180, 0), (190, 0), (200, 0), (210, 0), (220, 1), (230, 0), (240, 1), (250, 0), (260, 0), (270, 0), (280, 0), (290, 0), (300, 0), (310, 0), (320, 0), (330, 1), (340, 1), (350, 0), (360, 0), (370, 0), (380, 1), (390, 0), (400, 1), (410, 0), (420, 0), (430, 1), (440, 0), (450, 0), (460, 0), (470, 0), (480, 0), (490, 1), (500, 0), (510, 0), (520, 1), (530, 0), (540, 0), (550, 0), (560, 1), (570, 0), (580, 0), (590, 0), (600, 0), (610, 0), (620, 1), (630, 1), (640, 0), (650, 0), (660, 0), (670, 0), (680, 1), (690, 0), (700, 0), (710, 0), (720, 0), (730, 0), (740, 0), (750, 0), (760, 1), (770, 0), (780, 1), (790, 1), (800, 0), (810, 0), (820, 0), (830, 0), (840, 0), (850, 0), (860, 0), (870, 0), (880, 0), (890, 0), (900, 1), (910, 0), (920, 0), (930, 0), (940, 0), (950, 0), (960, 0), (970, 0), (980, 0), (990, 0), (1000, 0), (1010, 0), (1020, 0), (1030, 0), (1040, 0), (1050, 1), (1060, 0), (1070, 0), (1080, 0), (1090, 1), (1100, 0), (1110, 0), (1120, 1), (1130, 1), (1140, 0), (1150, 0), (1160, 0), (1170, 0), (1180, 0), (1190, 0), (1200, 1), (1210, 0), (1220, 0), (1230, 0), (1240, 0), (1250, 0), (1260, 0), (1270, 1), (1280, 0), (1290, 0), (1300, 0), (1310, 0), (1320, 0), (1330, 0), (1340, 1), (1350, 0), (1360, 0), (1370, 1), (1380, 0), (1390, 1), (1400, 0), (1410, 0), (1420, 1), (1430, 0), (1440, 0), (1450, 0), (1460, 1), (1470, 0), (1480, 0), (1490, 1), (1500, 0), (1510, 0), (1520, 0), (1530, 0), (1540, 1), (1550, 0), (1560, 0), (1570, 1), (1580, 0), (1590, 0), (1600, 0), (1610, 1), (1620, 1), (1630, 0), (1640, 0), (1650, 1), (1660, 1), (1670, 0), (1680, 0), (1690, 1), (1700, 0), (1710, 0), (1720, 0), (1730, 0), (1740, 0), (1750, 0), (1760, 1), (1770, 0), (1780, 0), (1790, 0), (1800, 0), (1810, 0), (1820, 0), (1830, 0), (1840, 1), (1850, 0), (1860, 0), (1870, 1), (1880, 0), (1890, 1), (1900, 1), (1910, 0), (1920, 0), (1930, 0), (1940, 0), (1950, 0), (1960, 1), (1970, 0), (1980, 1), (1990, 0), (2000, 1), (2010, 0), (2020, 0), (2030, 1), (2040, 0), (2050, 1)]
VCSB0 CSB0 0 PWL (0n 5.0v 9.45n 5.0v 9.55n 0.0v 19.45n 0.0v 19.55n 0.0v 29.45n 0.0v 29.55n 0.0v 39.45n 0.0v 39.55n 0.0v 49.45n 0.0v 49.55n 0.0v 59.45n 0.0v 59.55n 0.0v 69.45n 0.0v 69.55n 0.0v 79.45n 0.0v 79.55n 5.0v 89.45n 5.0v 89.55n 5.0v 99.45n 5.0v 99.55n 0.0v 109.45n 0.0v 109.55n 5.0v 119.45n 5.0v 119.55n 0.0v 129.45n 0.0v 129.55n 0.0v 139.45n 0.0v 139.55n 5.0v 149.45n 5.0v 149.55n 5.0v 159.45n 5.0v 159.55n 5.0v 169.45n 5.0v 169.55n 0.0v 179.45n 0.0v 179.55n 0.0v 189.45n 0.0v 189.55n 0.0v 199.45n 0.0v 199.55n 0.0v 209.45n 0.0v 209.55n 0.0v 219.45n 0.0v 219.55n 5.0v 229.45n 5.0v 229.55n 0.0v 239.45n 0.0v 239.55n 5.0v 249.45n 5.0v 249.55n 0.0v 259.45n 0.0v 259.55n 0.0v 269.45n 0.0v 269.55n 0.0v 279.45n 0.0v 279.55n 0.0v 289.45n 0.0v 289.55n 0.0v 299.45n 0.0v 299.55n 0.0v 309.45n 0.0v 309.55n 0.0v 319.45n 0.0v 319.55n 0.0v 329.45n 0.0v 329.55n 5.0v 339.45n 5.0v 339.55n 5.0v 349.45n 5.0v 349.55n 0.0v 359.45n 0.0v 359.55n 0.0v 369.45n 0.0v 369.55n 0.0v 379.45n 0.0v 379.55n 5.0v 389.45n 5.0v 389.55n 0.0v 399.45n 0.0v 399.55n 5.0v 409.45n 5.0v 409.55n 0.0v 419.45n 0.0v 419.55n 0.0v 429.45n 0.0v 429.55n 5.0v 439.45n 5.0v 439.55n 0.0v 449.45n 0.0v 449.55n 0.0v 459.45n 0.0v 459.55n 0.0v 469.45n 0.0v 469.55n 0.0v 479.45n 0.0v 479.55n 0.0v 489.45n 0.0v 489.55n 5.0v 499.45n 5.0v 499.55n 0.0v 509.45n 0.0v 509.55n 0.0v 519.45n 0.0v 519.55n 5.0v 529.45n 5.0v 529.55n 0.0v 539.45n 0.0v 539.55n 0.0v 549.45n 0.0v 549.55n 0.0v 559.45n 0.0v 559.55n 5.0v 569.45n 5.0v 569.55n 0.0v 579.45n 0.0v 579.55n 0.0v 589.45n 0.0v 589.55n 0.0v 599.45n 0.0v 599.55n 0.0v 609.45n 0.0v 609.55n 0.0v 619.45n 0.0v 619.55n 5.0v 629.45n 5.0v 629.55n 5.0v 639.45n 5.0v 639.55n 0.0v 649.45n 0.0v 649.55n 0.0v 659.45n 0.0v 659.55n 0.0v 669.45n 0.0v 669.55n 0.0v 679.45n 0.0v 679.55n 5.0v 689.45n 5.0v 689.55n 0.0v 699.45n 0.0v 699.55n 0.0v 709.45n 0.0v 709.55n 0.0v 719.45n 0.0v 719.55n 0.0v 729.45n 0.0v 729.55n 0.0v 739.45n 0.0v 739.55n 0.0v 749.45n 0.0v 749.55n 0.0v 759.45n 0.0v 759.55n 5.0v 769.45n 5.0v 769.55n 0.0v 779.45n 0.0v 779.55n 5.0v 789.45n 5.0v 789.55n 5.0v 799.45n 5.0v 799.55n 0.0v 809.45n 0.0v 809.55n 0.0v 819.45n 0.0v 819.55n 0.0v 829.45n 0.0v 829.55n 0.0v 839.45n 0.0v 839.55n 0.0v 849.45n 0.0v 849.55n 0.0v 859.45n 0.0v 859.55n 0.0v 869.45n 0.0v 869.55n 0.0v 879.45n 0.0v 879.55n 0.0v 889.45n 0.0v 889.55n 0.0v 899.45n 0.0v 899.55n 5.0v 909.45n 5.0v 909.55n 0.0v 919.45n 0.0v 919.55n 0.0v 929.45n 0.0v 929.55n 0.0v 939.45n 0.0v 939.55n 0.0v 949.45n 0.0v 949.55n 0.0v 959.45n 0.0v 959.55n 0.0v 969.45n 0.0v 969.55n 0.0v 979.45n 0.0v 979.55n 0.0v 989.45n 0.0v 989.55n 0.0v 999.45n 0.0v 999.55n 0.0v 1009.45n 0.0v 1009.55n 0.0v 1019.45n 0.0v 1019.55n 0.0v 1029.45n 0.0v 1029.55n 0.0v 1039.45n 0.0v 1039.55n 0.0v 1049.45n 0.0v 1049.55n 5.0v 1059.45n 5.0v 1059.55n 0.0v 1069.45n 0.0v 1069.55n 0.0v 1079.45n 0.0v 1079.55n 0.0v 1089.45n 0.0v 1089.55n 5.0v 1099.45n 5.0v 1099.55n 0.0v 1109.45n 0.0v 1109.55n 0.0v 1119.45n 0.0v 1119.55n 5.0v 1129.45n 5.0v 1129.55n 5.0v 1139.45n 5.0v 1139.55n 0.0v 1149.45n 0.0v 1149.55n 0.0v 1159.45n 0.0v 1159.55n 0.0v 1169.45n 0.0v 1169.55n 0.0v 1179.45n 0.0v 1179.55n 0.0v 1189.45n 0.0v 1189.55n 0.0v 1199.45n 0.0v 1199.55n 5.0v 1209.45n 5.0v 1209.55n 0.0v 1219.45n 0.0v 1219.55n 0.0v 1229.45n 0.0v 1229.55n 0.0v 1239.45n 0.0v 1239.55n 0.0v 1249.45n 0.0v 1249.55n 0.0v 1259.45n 0.0v 1259.55n 0.0v 1269.45n 0.0v 1269.55n 5.0v 1279.45n 5.0v 1279.55n 0.0v 1289.45n 0.0v 1289.55n 0.0v 1299.45n 0.0v 1299.55n 0.0v 1309.45n 0.0v 1309.55n 0.0v 1319.45n 0.0v 1319.55n 0.0v 1329.45n 0.0v 1329.55n 0.0v 1339.45n 0.0v 1339.55n 5.0v 1349.45n 5.0v 1349.55n 0.0v 1359.45n 0.0v 1359.55n 0.0v 1369.45n 0.0v 1369.55n 5.0v 1379.45n 5.0v 1379.55n 0.0v 1389.45n 0.0v 1389.55n 5.0v 1399.45n 5.0v 1399.55n 0.0v 1409.45n 0.0v 1409.55n 0.0v 1419.45n 0.0v 1419.55n 5.0v 1429.45n 5.0v 1429.55n 0.0v 1439.45n 0.0v 1439.55n 0.0v 1449.45n 0.0v 1449.55n 0.0v 1459.45n 0.0v 1459.55n 5.0v 1469.45n 5.0v 1469.55n 0.0v 1479.45n 0.0v 1479.55n 0.0v 1489.45n 0.0v 1489.55n 5.0v 1499.45n 5.0v 1499.55n 0.0v 1509.45n 0.0v 1509.55n 0.0v 1519.45n 0.0v 1519.55n 0.0v 1529.45n 0.0v 1529.55n 0.0v 1539.45n 0.0v 1539.55n 5.0v 1549.45n 5.0v 1549.55n 0.0v 1559.45n 0.0v 1559.55n 0.0v 1569.45n 0.0v 1569.55n 5.0v 1579.45n 5.0v 1579.55n 0.0v 1589.45n 0.0v 1589.55n 0.0v 1599.45n 0.0v 1599.55n 0.0v 1609.45n 0.0v 1609.55n 5.0v 1619.45n 5.0v 1619.55n 5.0v 1629.45n 5.0v 1629.55n 0.0v 1639.45n 0.0v 1639.55n 0.0v 1649.45n 0.0v 1649.55n 5.0v 1659.45n 5.0v 1659.55n 5.0v 1669.45n 5.0v 1669.55n 0.0v 1679.45n 0.0v 1679.55n 0.0v 1689.45n 0.0v 1689.55n 5.0v 1699.45n 5.0v 1699.55n 0.0v 1709.45n 0.0v 1709.55n 0.0v 1719.45n 0.0v 1719.55n 0.0v 1729.45n 0.0v 1729.55n 0.0v 1739.45n 0.0v 1739.55n 0.0v 1749.45n 0.0v 1749.55n 0.0v 1759.45n 0.0v 1759.55n 5.0v 1769.45n 5.0v 1769.55n 0.0v 1779.45n 0.0v 1779.55n 0.0v 1789.45n 0.0v 1789.55n 0.0v 1799.45n 0.0v 1799.55n 0.0v 1809.45n 0.0v 1809.55n 0.0v 1819.45n 0.0v 1819.55n 0.0v 1829.45n 0.0v 1829.55n 0.0v 1839.45n 0.0v 1839.55n 5.0v 1849.45n 5.0v 1849.55n 0.0v 1859.45n 0.0v 1859.55n 0.0v 1869.45n 0.0v 1869.55n 5.0v 1879.45n 5.0v 1879.55n 0.0v 1889.45n 0.0v 1889.55n 5.0v 1899.45n 5.0v 1899.55n 5.0v 1909.45n 5.0v 1909.55n 0.0v 1919.45n 0.0v 1919.55n 0.0v 1929.45n 0.0v 1929.55n 0.0v 1939.45n 0.0v 1939.55n 0.0v 1949.45n 0.0v 1949.55n 0.0v 1959.45n 0.0v 1959.55n 5.0v 1969.45n 5.0v 1969.55n 0.0v 1979.45n 0.0v 1979.55n 5.0v 1989.45n 5.0v 1989.55n 0.0v 1999.45n 0.0v 1999.55n 5.0v 2009.45n 5.0v 2009.55n 0.0v 2019.45n 0.0v 2019.55n 0.0v 2029.45n 0.0v 2029.55n 5.0v 2039.45n 5.0v 2039.55n 0.0v 2049.45n 0.0v 2049.55n 5.0v )
* (time, data): [(0, 1), (10, 0), (20, 0), (30, 0), (40, 1), (50, 1), (60, 1), (70, 1), (80, 1), (90, 1), (100, 1), (110, 1), (120, 0), (130, 0), (140, 1), (150, 1), (160, 1), (170, 0), (180, 0), (190, 1), (200, 1), (210, 1), (220, 1), (230, 1), (240, 1), (250, 1), (260, 1), (270, 1), (280, 1), (290, 0), (300, 0), (310, 1), (320, 1), (330, 1), (340, 1), (350, 0), (360, 0), (370, 1), (380, 1), (390, 1), (400, 1), (410, 1), (420, 0), (430, 1), (440, 1), (450, 0), (460, 1), (470, 1), (480, 1), (490, 1), (500, 0), (510, 1), (520, 1), (530, 1), (540, 1), (550, 1), (560, 1), (570, 1), (580, 1), (590, 1), (600, 1), (610, 1), (620, 1), (630, 1), (640, 0), (650, 0), (660, 1), (670, 1), (680, 1), (690, 1), (700, 0), (710, 1), (720, 1), (730, 1), (740, 1), (750, 0), (760, 1), (770, 1), (780, 1), (790, 1), (800, 1), (810, 1), (820, 1), (830, 1), (840, 0), (850, 1), (860, 1), (870, 1), (880, 0), (890, 1), (900, 1), (910, 1), (920, 1), (930, 1), (940, 0), (950, 0), (960, 1), (970, 1), (980, 1), (990, 0), (1000, 1), (1010, 1), (1020, 1), (1030, 0), (1040, 0), (1050, 1), (1060, 1), (1070, 0), (1080, 1), (1090, 1), (1100, 1), (1110, 1), (1120, 1), (1130, 1), (1140, 1), (1150, 0), (1160, 0), (1170, 1), (1180, 0), (1190, 1), (1200, 1), (1210, 0), (1220, 0), (1230, 1), (1240, 0), (1250, 1), (1260, 1), (1270, 1), (1280, 0), (1290, 0), (1300, 1), (1310, 1), (1320, 0), (1330, 1), (1340, 1), (1350, 1), (1360, 0), (1370, 1), (1380, 1), (1390, 1), (1400, 0), (1410, 1), (1420, 1), (1430, 1), (1440, 1), (1450, 1), (1460, 1), (1470, 1), (1480, 1), (1490, 1), (1500, 1), (1510, 1), (1520, 1), (1530, 0), (1540, 1), (1550, 1), (1560, 1), (1570, 1), (1580, 1), (1590, 1), (1600, 1), (1610, 1), (1620, 1), (1630, 1), (1640, 1), (1650, 1), (1660, 1), (1670, 0), (1680, 1), (1690, 1), (1700, 1), (1710, 1), (1720, 0), (1730, 0), (1740, 0), (1750, 0), (1760, 1), (1770, 1), (1780, 1), (1790, 0), (1800, 1), (1810, 0), (1820, 1), (1830, 1), (1840, 1), (1850, 0), (1860, 1), (1870, 1), (1880, 1), (1890, 1), (1900, 1), (1910, 1), (1920, 1), (1930, 1), (1940, 1), (1950, 1), (1960, 1), (1970, 0), (1980, 1), (1990, 1), (2000, 1), (2010, 1), (2020, 1), (2030, 1), (2040, 1), (2050, 1)]
VWEB0 WEB0 0 PWL (0n 5.0v 9.45n 5.0v 9.55n 0.0v 19.45n 0.0v 19.55n 0.0v 29.45n 0.0v 29.55n 0.0v 39.45n 0.0v 39.55n 5.0v 49.45n 5.0v 49.55n 5.0v 59.45n 5.0v 59.55n 5.0v 69.45n 5.0v 69.55n 5.0v 79.45n 5.0v 79.55n 5.0v 89.45n 5.0v 89.55n 5.0v 99.45n 5.0v 99.55n 5.0v 109.45n 5.0v 109.55n 5.0v 119.45n 5.0v 119.55n 0.0v 129.45n 0.0v 129.55n 0.0v 139.45n 0.0v 139.55n 5.0v 149.45n 5.0v 149.55n 5.0v 159.45n 5.0v 159.55n 5.0v 169.45n 5.0v 169.55n 0.0v 179.45n 0.0v 179.55n 0.0v 189.45n 0.0v 189.55n 5.0v 199.45n 5.0v 199.55n 5.0v 209.45n 5.0v 209.55n 5.0v 219.45n 5.0v 219.55n 5.0v 229.45n 5.0v 229.55n 5.0v 239.45n 5.0v 239.55n 5.0v 249.45n 5.0v 249.55n 5.0v 259.45n 5.0v 259.55n 5.0v 269.45n 5.0v 269.55n 5.0v 279.45n 5.0v 279.55n 5.0v 289.45n 5.0v 289.55n 0.0v 299.45n 0.0v 299.55n 0.0v 309.45n 0.0v 309.55n 5.0v 319.45n 5.0v 319.55n 5.0v 329.45n 5.0v 329.55n 5.0v 339.45n 5.0v 339.55n 5.0v 349.45n 5.0v 349.55n 0.0v 359.45n 0.0v 359.55n 0.0v 369.45n 0.0v 369.55n 5.0v 379.45n 5.0v 379.55n 5.0v 389.45n 5.0v 389.55n 5.0v 399.45n 5.0v 399.55n 5.0v 409.45n 5.0v 409.55n 5.0v 419.45n 5.0v 419.55n 0.0v 429.45n 0.0v 429.55n 5.0v 439.45n 5.0v 439.55n 5.0v 449.45n 5.0v 449.55n 0.0v 459.45n 0.0v 459.55n 5.0v 469.45n 5.0v 469.55n 5.0v 479.45n 5.0v 479.55n 5.0v 489.45n 5.0v 489.55n 5.0v 499.45n 5.0v 499.55n 0.0v 509.45n 0.0v 509.55n 5.0v 519.45n 5.0v 519.55n 5.0v 529.45n 5.0v 529.55n 5.0v 539.45n 5.0v 539.55n 5.0v 549.45n 5.0v 549.55n 5.0v 559.45n 5.0v 559.55n 5.0v 569.45n 5.0v 569.55n 5.0v 579.45n 5.0v 579.55n 5.0v 589.45n 5.0v 589.55n 5.0v 599.45n 5.0v 599.55n 5.0v 609.45n 5.0v 609.55n 5.0v 619.45n 5.0v 619.55n 5.0v 629.45n 5.0v 629.55n 5.0v 639.45n 5.0v 639.55n 0.0v 649.45n 0.0v 649.55n 0.0v 659.45n 0.0v 659.55n 5.0v 669.45n 5.0v 669.55n 5.0v 679.45n 5.0v 679.55n 5.0v 689.45n 5.0v 689.55n 5.0v 699.45n 5.0v 699.55n 0.0v 709.45n 0.0v 709.55n 5.0v 719.45n 5.0v 719.55n 5.0v 729.45n 5.0v 729.55n 5.0v 739.45n 5.0v 739.55n 5.0v 749.45n 5.0v 749.55n 0.0v 759.45n 0.0v 759.55n 5.0v 769.45n 5.0v 769.55n 5.0v 779.45n 5.0v 779.55n 5.0v 789.45n 5.0v 789.55n 5.0v 799.45n 5.0v 799.55n 5.0v 809.45n 5.0v 809.55n 5.0v 819.45n 5.0v 819.55n 5.0v 829.45n 5.0v 829.55n 5.0v 839.45n 5.0v 839.55n 0.0v 849.45n 0.0v 849.55n 5.0v 859.45n 5.0v 859.55n 5.0v 869.45n 5.0v 869.55n 5.0v 879.45n 5.0v 879.55n 0.0v 889.45n 0.0v 889.55n 5.0v 899.45n 5.0v 899.55n 5.0v 909.45n 5.0v 909.55n 5.0v 919.45n 5.0v 919.55n 5.0v 929.45n 5.0v 929.55n 5.0v 939.45n 5.0v 939.55n 0.0v 949.45n 0.0v 949.55n 0.0v 959.45n 0.0v 959.55n 5.0v 969.45n 5.0v 969.55n 5.0v 979.45n 5.0v 979.55n 5.0v 989.45n 5.0v 989.55n 0.0v 999.45n 0.0v 999.55n 5.0v 1009.45n 5.0v 1009.55n 5.0v 1019.45n 5.0v 1019.55n 5.0v 1029.45n 5.0v 1029.55n 0.0v 1039.45n 0.0v 1039.55n 0.0v 1049.45n 0.0v 1049.55n 5.0v 1059.45n 5.0v 1059.55n 5.0v 1069.45n 5.0v 1069.55n 0.0v 1079.45n 0.0v 1079.55n 5.0v 1089.45n 5.0v 1089.55n 5.0v 1099.45n 5.0v 1099.55n 5.0v 1109.45n 5.0v 1109.55n 5.0v 1119.45n 5.0v 1119.55n 5.0v 1129.45n 5.0v 1129.55n 5.0v 1139.45n 5.0v 1139.55n 5.0v 1149.45n 5.0v 1149.55n 0.0v 1159.45n 0.0v 1159.55n 0.0v 1169.45n 0.0v 1169.55n 5.0v 1179.45n 5.0v 1179.55n 0.0v 1189.45n 0.0v 1189.55n 5.0v 1199.45n 5.0v 1199.55n 5.0v 1209.45n 5.0v 1209.55n 0.0v 1219.45n 0.0v 1219.55n 0.0v 1229.45n 0.0v 1229.55n 5.0v 1239.45n 5.0v 1239.55n 0.0v 1249.45n 0.0v 1249.55n 5.0v 1259.45n 5.0v 1259.55n 5.0v 1269.45n 5.0v 1269.55n 5.0v 1279.45n 5.0v 1279.55n 0.0v 1289.45n 0.0v 1289.55n 0.0v 1299.45n 0.0v 1299.55n 5.0v 1309.45n 5.0v 1309.55n 5.0v 1319.45n 5.0v 1319.55n 0.0v 1329.45n 0.0v 1329.55n 5.0v 1339.45n 5.0v 1339.55n 5.0v 1349.45n 5.0v 1349.55n 5.0v 1359.45n 5.0v 1359.55n 0.0v 1369.45n 0.0v 1369.55n 5.0v 1379.45n 5.0v 1379.55n 5.0v 1389.45n 5.0v 1389.55n 5.0v 1399.45n 5.0v 1399.55n 0.0v 1409.45n 0.0v 1409.55n 5.0v 1419.45n 5.0v 1419.55n 5.0v 1429.45n 5.0v 1429.55n 5.0v 1439.45n 5.0v 1439.55n 5.0v 1449.45n 5.0v 1449.55n 5.0v 1459.45n 5.0v 1459.55n 5.0v 1469.45n 5.0v 1469.55n 5.0v 1479.45n 5.0v 1479.55n 5.0v 1489.45n 5.0v 1489.55n 5.0v 1499.45n 5.0v 1499.55n 5.0v 1509.45n 5.0v 1509.55n 5.0v 1519.45n 5.0v 1519.55n 5.0v 1529.45n 5.0v 1529.55n 0.0v 1539.45n 0.0v 1539.55n 5.0v 1549.45n 5.0v 1549.55n 5.0v 1559.45n 5.0v 1559.55n 5.0v 1569.45n 5.0v 1569.55n 5.0v 1579.45n 5.0v 1579.55n 5.0v 1589.45n 5.0v 1589.55n 5.0v 1599.45n 5.0v 1599.55n 5.0v 1609.45n 5.0v 1609.55n 5.0v 1619.45n 5.0v 1619.55n 5.0v 1629.45n 5.0v 1629.55n 5.0v 1639.45n 5.0v 1639.55n 5.0v 1649.45n 5.0v 1649.55n 5.0v 1659.45n 5.0v 1659.55n 5.0v 1669.45n 5.0v 1669.55n 0.0v 1679.45n 0.0v 1679.55n 5.0v 1689.45n 5.0v 1689.55n 5.0v 1699.45n 5.0v 1699.55n 5.0v 1709.45n 5.0v 1709.55n 5.0v 1719.45n 5.0v 1719.55n 0.0v 1729.45n 0.0v 1729.55n 0.0v 1739.45n 0.0v 1739.55n 0.0v 1749.45n 0.0v 1749.55n 0.0v 1759.45n 0.0v 1759.55n 5.0v 1769.45n 5.0v 1769.55n 5.0v 1779.45n 5.0v 1779.55n 5.0v 1789.45n 5.0v 1789.55n 0.0v 1799.45n 0.0v 1799.55n 5.0v 1809.45n 5.0v 1809.55n 0.0v 1819.45n 0.0v 1819.55n 5.0v 1829.45n 5.0v 1829.55n 5.0v 1839.45n 5.0v 1839.55n 5.0v 1849.45n 5.0v 1849.55n 0.0v 1859.45n 0.0v 1859.55n 5.0v 1869.45n 5.0v 1869.55n 5.0v 1879.45n 5.0v 1879.55n 5.0v 1889.45n 5.0v 1889.55n 5.0v 1899.45n 5.0v 1899.55n 5.0v 1909.45n 5.0v 1909.55n 5.0v 1919.45n 5.0v 1919.55n 5.0v 1929.45n 5.0v 1929.55n 5.0v 1939.45n 5.0v 1939.55n 5.0v 1949.45n 5.0v 1949.55n 5.0v 1959.45n 5.0v 1959.55n 5.0v 1969.45n 5.0v 1969.55n 0.0v 1979.45n 0.0v 1979.55n 5.0v 1989.45n 5.0v 1989.55n 5.0v 1999.45n 5.0v 1999.55n 5.0v 2009.45n 5.0v 2009.55n 5.0v 2019.45n 5.0v 2019.55n 5.0v 2029.45n 5.0v 2029.55n 5.0v 2039.45n 5.0v 2039.55n 5.0v 2049.45n 5.0v 2049.55n 5.0v )
* PULSE: period=10
Vclk0 clk0 0 PULSE (0 5.0 9.95n 0.1n 0.1n 4.9n 10n)

 * Generation of dout measurements
* CHECK dout0_0 vdout0_0ck4 = 0 time = 50
* CHECK dout0_1 vdout0_1ck4 = 0 time = 50
* CHECK dout0_2 vdout0_2ck4 = 0 time = 50
* CHECK dout0_3 vdout0_3ck4 = 5.0 time = 50
* CHECK dout0_4 vdout0_4ck4 = 0 time = 50
* CHECK dout0_5 vdout0_5ck4 = 0 time = 50
* CHECK dout0_6 vdout0_6ck4 = 5.0 time = 50
* CHECK dout0_7 vdout0_7ck4 = 5.0 time = 50
* CHECK dout0_8 vdout0_8ck4 = 5.0 time = 50
* CHECK dout0_9 vdout0_9ck4 = 0 time = 50
* CHECK dout0_10 vdout0_10ck4 = 0 time = 50
* CHECK dout0_11 vdout0_11ck4 = 0 time = 50
* CHECK dout0_12 vdout0_12ck4 = 5.0 time = 50
* CHECK dout0_13 vdout0_13ck4 = 0 time = 50
* CHECK dout0_14 vdout0_14ck4 = 5.0 time = 50
* CHECK dout0_15 vdout0_15ck4 = 0 time = 50
* CHECK dout0_0 vdout0_0ck5 = 0 time = 60
* CHECK dout0_1 vdout0_1ck5 = 0 time = 60
* CHECK dout0_2 vdout0_2ck5 = 0 time = 60
* CHECK dout0_3 vdout0_3ck5 = 5.0 time = 60
* CHECK dout0_4 vdout0_4ck5 = 0 time = 60
* CHECK dout0_5 vdout0_5ck5 = 0 time = 60
* CHECK dout0_6 vdout0_6ck5 = 5.0 time = 60
* CHECK dout0_7 vdout0_7ck5 = 5.0 time = 60
* CHECK dout0_8 vdout0_8ck5 = 5.0 time = 60
* CHECK dout0_9 vdout0_9ck5 = 0 time = 60
* CHECK dout0_10 vdout0_10ck5 = 0 time = 60
* CHECK dout0_11 vdout0_11ck5 = 0 time = 60
* CHECK dout0_12 vdout0_12ck5 = 5.0 time = 60
* CHECK dout0_13 vdout0_13ck5 = 0 time = 60
* CHECK dout0_14 vdout0_14ck5 = 5.0 time = 60
* CHECK dout0_15 vdout0_15ck5 = 0 time = 60
* CHECK dout0_0 vdout0_0ck6 = 0 time = 70
* CHECK dout0_1 vdout0_1ck6 = 0 time = 70
* CHECK dout0_2 vdout0_2ck6 = 0 time = 70
* CHECK dout0_3 vdout0_3ck6 = 5.0 time = 70
* CHECK dout0_4 vdout0_4ck6 = 0 time = 70
* CHECK dout0_5 vdout0_5ck6 = 0 time = 70
* CHECK dout0_6 vdout0_6ck6 = 5.0 time = 70
* CHECK dout0_7 vdout0_7ck6 = 5.0 time = 70
* CHECK dout0_8 vdout0_8ck6 = 5.0 time = 70
* CHECK dout0_9 vdout0_9ck6 = 0 time = 70
* CHECK dout0_10 vdout0_10ck6 = 0 time = 70
* CHECK dout0_11 vdout0_11ck6 = 0 time = 70
* CHECK dout0_12 vdout0_12ck6 = 5.0 time = 70
* CHECK dout0_13 vdout0_13ck6 = 0 time = 70
* CHECK dout0_14 vdout0_14ck6 = 5.0 time = 70
* CHECK dout0_15 vdout0_15ck6 = 0 time = 70
* CHECK dout0_0 vdout0_0ck7 = 0 time = 80
* CHECK dout0_1 vdout0_1ck7 = 0 time = 80
* CHECK dout0_2 vdout0_2ck7 = 0 time = 80
* CHECK dout0_3 vdout0_3ck7 = 5.0 time = 80
* CHECK dout0_4 vdout0_4ck7 = 0 time = 80
* CHECK dout0_5 vdout0_5ck7 = 0 time = 80
* CHECK dout0_6 vdout0_6ck7 = 5.0 time = 80
* CHECK dout0_7 vdout0_7ck7 = 5.0 time = 80
* CHECK dout0_8 vdout0_8ck7 = 5.0 time = 80
* CHECK dout0_9 vdout0_9ck7 = 0 time = 80
* CHECK dout0_10 vdout0_10ck7 = 0 time = 80
* CHECK dout0_11 vdout0_11ck7 = 0 time = 80
* CHECK dout0_12 vdout0_12ck7 = 5.0 time = 80
* CHECK dout0_13 vdout0_13ck7 = 0 time = 80
* CHECK dout0_14 vdout0_14ck7 = 5.0 time = 80
* CHECK dout0_15 vdout0_15ck7 = 0 time = 80
* CHECK dout0_0 vdout0_0ck10 = 0 time = 110
* CHECK dout0_1 vdout0_1ck10 = 0 time = 110
* CHECK dout0_2 vdout0_2ck10 = 0 time = 110
* CHECK dout0_3 vdout0_3ck10 = 5.0 time = 110
* CHECK dout0_4 vdout0_4ck10 = 0 time = 110
* CHECK dout0_5 vdout0_5ck10 = 0 time = 110
* CHECK dout0_6 vdout0_6ck10 = 5.0 time = 110
* CHECK dout0_7 vdout0_7ck10 = 5.0 time = 110
* CHECK dout0_8 vdout0_8ck10 = 5.0 time = 110
* CHECK dout0_9 vdout0_9ck10 = 0 time = 110
* CHECK dout0_10 vdout0_10ck10 = 0 time = 110
* CHECK dout0_11 vdout0_11ck10 = 0 time = 110
* CHECK dout0_12 vdout0_12ck10 = 5.0 time = 110
* CHECK dout0_13 vdout0_13ck10 = 0 time = 110
* CHECK dout0_14 vdout0_14ck10 = 5.0 time = 110
* CHECK dout0_15 vdout0_15ck10 = 0 time = 110
* CHECK dout0_0 vdout0_0ck19 = 0 time = 200
* CHECK dout0_1 vdout0_1ck19 = 5.0 time = 200
* CHECK dout0_2 vdout0_2ck19 = 0 time = 200
* CHECK dout0_3 vdout0_3ck19 = 0 time = 200
* CHECK dout0_4 vdout0_4ck19 = 0 time = 200
* CHECK dout0_5 vdout0_5ck19 = 0 time = 200
* CHECK dout0_6 vdout0_6ck19 = 5.0 time = 200
* CHECK dout0_7 vdout0_7ck19 = 5.0 time = 200
* CHECK dout0_8 vdout0_8ck19 = 0 time = 200
* CHECK dout0_9 vdout0_9ck19 = 0 time = 200
* CHECK dout0_10 vdout0_10ck19 = 5.0 time = 200
* CHECK dout0_11 vdout0_11ck19 = 5.0 time = 200
* CHECK dout0_12 vdout0_12ck19 = 0 time = 200
* CHECK dout0_13 vdout0_13ck19 = 0 time = 200
* CHECK dout0_14 vdout0_14ck19 = 5.0 time = 200
* CHECK dout0_15 vdout0_15ck19 = 5.0 time = 200
* CHECK dout0_0 vdout0_0ck20 = 0 time = 210
* CHECK dout0_1 vdout0_1ck20 = 5.0 time = 210
* CHECK dout0_2 vdout0_2ck20 = 0 time = 210
* CHECK dout0_3 vdout0_3ck20 = 0 time = 210
* CHECK dout0_4 vdout0_4ck20 = 0 time = 210
* CHECK dout0_5 vdout0_5ck20 = 0 time = 210
* CHECK dout0_6 vdout0_6ck20 = 5.0 time = 210
* CHECK dout0_7 vdout0_7ck20 = 5.0 time = 210
* CHECK dout0_8 vdout0_8ck20 = 0 time = 210
* CHECK dout0_9 vdout0_9ck20 = 0 time = 210
* CHECK dout0_10 vdout0_10ck20 = 5.0 time = 210
* CHECK dout0_11 vdout0_11ck20 = 5.0 time = 210
* CHECK dout0_12 vdout0_12ck20 = 0 time = 210
* CHECK dout0_13 vdout0_13ck20 = 0 time = 210
* CHECK dout0_14 vdout0_14ck20 = 5.0 time = 210
* CHECK dout0_15 vdout0_15ck20 = 5.0 time = 210
* CHECK dout0_0 vdout0_0ck21 = 0 time = 220
* CHECK dout0_1 vdout0_1ck21 = 5.0 time = 220
* CHECK dout0_2 vdout0_2ck21 = 0 time = 220
* CHECK dout0_3 vdout0_3ck21 = 0 time = 220
* CHECK dout0_4 vdout0_4ck21 = 0 time = 220
* CHECK dout0_5 vdout0_5ck21 = 0 time = 220
* CHECK dout0_6 vdout0_6ck21 = 5.0 time = 220
* CHECK dout0_7 vdout0_7ck21 = 5.0 time = 220
* CHECK dout0_8 vdout0_8ck21 = 0 time = 220
* CHECK dout0_9 vdout0_9ck21 = 0 time = 220
* CHECK dout0_10 vdout0_10ck21 = 5.0 time = 220
* CHECK dout0_11 vdout0_11ck21 = 5.0 time = 220
* CHECK dout0_12 vdout0_12ck21 = 0 time = 220
* CHECK dout0_13 vdout0_13ck21 = 0 time = 220
* CHECK dout0_14 vdout0_14ck21 = 5.0 time = 220
* CHECK dout0_15 vdout0_15ck21 = 5.0 time = 220
* CHECK dout0_0 vdout0_0ck23 = 0 time = 240
* CHECK dout0_1 vdout0_1ck23 = 5.0 time = 240
* CHECK dout0_2 vdout0_2ck23 = 0 time = 240
* CHECK dout0_3 vdout0_3ck23 = 0 time = 240
* CHECK dout0_4 vdout0_4ck23 = 0 time = 240
* CHECK dout0_5 vdout0_5ck23 = 0 time = 240
* CHECK dout0_6 vdout0_6ck23 = 5.0 time = 240
* CHECK dout0_7 vdout0_7ck23 = 5.0 time = 240
* CHECK dout0_8 vdout0_8ck23 = 0 time = 240
* CHECK dout0_9 vdout0_9ck23 = 0 time = 240
* CHECK dout0_10 vdout0_10ck23 = 5.0 time = 240
* CHECK dout0_11 vdout0_11ck23 = 5.0 time = 240
* CHECK dout0_12 vdout0_12ck23 = 0 time = 240
* CHECK dout0_13 vdout0_13ck23 = 0 time = 240
* CHECK dout0_14 vdout0_14ck23 = 5.0 time = 240
* CHECK dout0_15 vdout0_15ck23 = 5.0 time = 240
* CHECK dout0_0 vdout0_0ck25 = 0 time = 260
* CHECK dout0_1 vdout0_1ck25 = 5.0 time = 260
* CHECK dout0_2 vdout0_2ck25 = 0 time = 260
* CHECK dout0_3 vdout0_3ck25 = 0 time = 260
* CHECK dout0_4 vdout0_4ck25 = 0 time = 260
* CHECK dout0_5 vdout0_5ck25 = 0 time = 260
* CHECK dout0_6 vdout0_6ck25 = 5.0 time = 260
* CHECK dout0_7 vdout0_7ck25 = 5.0 time = 260
* CHECK dout0_8 vdout0_8ck25 = 0 time = 260
* CHECK dout0_9 vdout0_9ck25 = 0 time = 260
* CHECK dout0_10 vdout0_10ck25 = 5.0 time = 260
* CHECK dout0_11 vdout0_11ck25 = 5.0 time = 260
* CHECK dout0_12 vdout0_12ck25 = 0 time = 260
* CHECK dout0_13 vdout0_13ck25 = 0 time = 260
* CHECK dout0_14 vdout0_14ck25 = 5.0 time = 260
* CHECK dout0_15 vdout0_15ck25 = 5.0 time = 260
* CHECK dout0_0 vdout0_0ck26 = 0 time = 270
* CHECK dout0_1 vdout0_1ck26 = 5.0 time = 270
* CHECK dout0_2 vdout0_2ck26 = 0 time = 270
* CHECK dout0_3 vdout0_3ck26 = 0 time = 270
* CHECK dout0_4 vdout0_4ck26 = 0 time = 270
* CHECK dout0_5 vdout0_5ck26 = 0 time = 270
* CHECK dout0_6 vdout0_6ck26 = 5.0 time = 270
* CHECK dout0_7 vdout0_7ck26 = 5.0 time = 270
* CHECK dout0_8 vdout0_8ck26 = 0 time = 270
* CHECK dout0_9 vdout0_9ck26 = 0 time = 270
* CHECK dout0_10 vdout0_10ck26 = 5.0 time = 270
* CHECK dout0_11 vdout0_11ck26 = 5.0 time = 270
* CHECK dout0_12 vdout0_12ck26 = 0 time = 270
* CHECK dout0_13 vdout0_13ck26 = 0 time = 270
* CHECK dout0_14 vdout0_14ck26 = 5.0 time = 270
* CHECK dout0_15 vdout0_15ck26 = 5.0 time = 270
* CHECK dout0_0 vdout0_0ck27 = 0 time = 280
* CHECK dout0_1 vdout0_1ck27 = 5.0 time = 280
* CHECK dout0_2 vdout0_2ck27 = 0 time = 280
* CHECK dout0_3 vdout0_3ck27 = 0 time = 280
* CHECK dout0_4 vdout0_4ck27 = 0 time = 280
* CHECK dout0_5 vdout0_5ck27 = 0 time = 280
* CHECK dout0_6 vdout0_6ck27 = 5.0 time = 280
* CHECK dout0_7 vdout0_7ck27 = 5.0 time = 280
* CHECK dout0_8 vdout0_8ck27 = 0 time = 280
* CHECK dout0_9 vdout0_9ck27 = 0 time = 280
* CHECK dout0_10 vdout0_10ck27 = 5.0 time = 280
* CHECK dout0_11 vdout0_11ck27 = 5.0 time = 280
* CHECK dout0_12 vdout0_12ck27 = 0 time = 280
* CHECK dout0_13 vdout0_13ck27 = 0 time = 280
* CHECK dout0_14 vdout0_14ck27 = 5.0 time = 280
* CHECK dout0_15 vdout0_15ck27 = 5.0 time = 280
* CHECK dout0_0 vdout0_0ck28 = 0 time = 290
* CHECK dout0_1 vdout0_1ck28 = 5.0 time = 290
* CHECK dout0_2 vdout0_2ck28 = 0 time = 290
* CHECK dout0_3 vdout0_3ck28 = 0 time = 290
* CHECK dout0_4 vdout0_4ck28 = 0 time = 290
* CHECK dout0_5 vdout0_5ck28 = 0 time = 290
* CHECK dout0_6 vdout0_6ck28 = 5.0 time = 290
* CHECK dout0_7 vdout0_7ck28 = 5.0 time = 290
* CHECK dout0_8 vdout0_8ck28 = 0 time = 290
* CHECK dout0_9 vdout0_9ck28 = 0 time = 290
* CHECK dout0_10 vdout0_10ck28 = 5.0 time = 290
* CHECK dout0_11 vdout0_11ck28 = 5.0 time = 290
* CHECK dout0_12 vdout0_12ck28 = 0 time = 290
* CHECK dout0_13 vdout0_13ck28 = 0 time = 290
* CHECK dout0_14 vdout0_14ck28 = 5.0 time = 290
* CHECK dout0_15 vdout0_15ck28 = 5.0 time = 290
* CHECK dout0_0 vdout0_0ck31 = 0 time = 320
* CHECK dout0_1 vdout0_1ck31 = 0 time = 320
* CHECK dout0_2 vdout0_2ck31 = 0 time = 320
* CHECK dout0_3 vdout0_3ck31 = 0 time = 320
* CHECK dout0_4 vdout0_4ck31 = 0 time = 320
* CHECK dout0_5 vdout0_5ck31 = 5.0 time = 320
* CHECK dout0_6 vdout0_6ck31 = 0 time = 320
* CHECK dout0_7 vdout0_7ck31 = 5.0 time = 320
* CHECK dout0_8 vdout0_8ck31 = 0 time = 320
* CHECK dout0_9 vdout0_9ck31 = 0 time = 320
* CHECK dout0_10 vdout0_10ck31 = 5.0 time = 320
* CHECK dout0_11 vdout0_11ck31 = 0 time = 320
* CHECK dout0_12 vdout0_12ck31 = 0 time = 320
* CHECK dout0_13 vdout0_13ck31 = 0 time = 320
* CHECK dout0_14 vdout0_14ck31 = 5.0 time = 320
* CHECK dout0_15 vdout0_15ck31 = 5.0 time = 320
* CHECK dout0_0 vdout0_0ck32 = 0 time = 330
* CHECK dout0_1 vdout0_1ck32 = 5.0 time = 330
* CHECK dout0_2 vdout0_2ck32 = 0 time = 330
* CHECK dout0_3 vdout0_3ck32 = 0 time = 330
* CHECK dout0_4 vdout0_4ck32 = 0 time = 330
* CHECK dout0_5 vdout0_5ck32 = 0 time = 330
* CHECK dout0_6 vdout0_6ck32 = 5.0 time = 330
* CHECK dout0_7 vdout0_7ck32 = 5.0 time = 330
* CHECK dout0_8 vdout0_8ck32 = 0 time = 330
* CHECK dout0_9 vdout0_9ck32 = 0 time = 330
* CHECK dout0_10 vdout0_10ck32 = 5.0 time = 330
* CHECK dout0_11 vdout0_11ck32 = 5.0 time = 330
* CHECK dout0_12 vdout0_12ck32 = 0 time = 330
* CHECK dout0_13 vdout0_13ck32 = 0 time = 330
* CHECK dout0_14 vdout0_14ck32 = 5.0 time = 330
* CHECK dout0_15 vdout0_15ck32 = 5.0 time = 330
* CHECK dout0_0 vdout0_0ck37 = 5.0 time = 380
* CHECK dout0_1 vdout0_1ck37 = 0 time = 380
* CHECK dout0_2 vdout0_2ck37 = 5.0 time = 380
* CHECK dout0_3 vdout0_3ck37 = 0 time = 380
* CHECK dout0_4 vdout0_4ck37 = 5.0 time = 380
* CHECK dout0_5 vdout0_5ck37 = 5.0 time = 380
* CHECK dout0_6 vdout0_6ck37 = 0 time = 380
* CHECK dout0_7 vdout0_7ck37 = 0 time = 380
* CHECK dout0_8 vdout0_8ck37 = 0 time = 380
* CHECK dout0_9 vdout0_9ck37 = 0 time = 380
* CHECK dout0_10 vdout0_10ck37 = 0 time = 380
* CHECK dout0_11 vdout0_11ck37 = 0 time = 380
* CHECK dout0_12 vdout0_12ck37 = 0 time = 380
* CHECK dout0_13 vdout0_13ck37 = 5.0 time = 380
* CHECK dout0_14 vdout0_14ck37 = 0 time = 380
* CHECK dout0_15 vdout0_15ck37 = 5.0 time = 380
* CHECK dout0_0 vdout0_0ck39 = 5.0 time = 400
* CHECK dout0_1 vdout0_1ck39 = 5.0 time = 400
* CHECK dout0_2 vdout0_2ck39 = 5.0 time = 400
* CHECK dout0_3 vdout0_3ck39 = 5.0 time = 400
* CHECK dout0_4 vdout0_4ck39 = 5.0 time = 400
* CHECK dout0_5 vdout0_5ck39 = 5.0 time = 400
* CHECK dout0_6 vdout0_6ck39 = 0 time = 400
* CHECK dout0_7 vdout0_7ck39 = 5.0 time = 400
* CHECK dout0_8 vdout0_8ck39 = 0 time = 400
* CHECK dout0_9 vdout0_9ck39 = 5.0 time = 400
* CHECK dout0_10 vdout0_10ck39 = 0 time = 400
* CHECK dout0_11 vdout0_11ck39 = 0 time = 400
* CHECK dout0_12 vdout0_12ck39 = 5.0 time = 400
* CHECK dout0_13 vdout0_13ck39 = 0 time = 400
* CHECK dout0_14 vdout0_14ck39 = 5.0 time = 400
* CHECK dout0_15 vdout0_15ck39 = 5.0 time = 400
* CHECK dout0_0 vdout0_0ck41 = 5.0 time = 420
* CHECK dout0_1 vdout0_1ck41 = 5.0 time = 420
* CHECK dout0_2 vdout0_2ck41 = 5.0 time = 420
* CHECK dout0_3 vdout0_3ck41 = 5.0 time = 420
* CHECK dout0_4 vdout0_4ck41 = 5.0 time = 420
* CHECK dout0_5 vdout0_5ck41 = 5.0 time = 420
* CHECK dout0_6 vdout0_6ck41 = 0 time = 420
* CHECK dout0_7 vdout0_7ck41 = 5.0 time = 420
* CHECK dout0_8 vdout0_8ck41 = 0 time = 420
* CHECK dout0_9 vdout0_9ck41 = 5.0 time = 420
* CHECK dout0_10 vdout0_10ck41 = 0 time = 420
* CHECK dout0_11 vdout0_11ck41 = 0 time = 420
* CHECK dout0_12 vdout0_12ck41 = 5.0 time = 420
* CHECK dout0_13 vdout0_13ck41 = 0 time = 420
* CHECK dout0_14 vdout0_14ck41 = 5.0 time = 420
* CHECK dout0_15 vdout0_15ck41 = 5.0 time = 420
* CHECK dout0_0 vdout0_0ck44 = 0 time = 450
* CHECK dout0_1 vdout0_1ck44 = 0 time = 450
* CHECK dout0_2 vdout0_2ck44 = 5.0 time = 450
* CHECK dout0_3 vdout0_3ck44 = 5.0 time = 450
* CHECK dout0_4 vdout0_4ck44 = 0 time = 450
* CHECK dout0_5 vdout0_5ck44 = 0 time = 450
* CHECK dout0_6 vdout0_6ck44 = 5.0 time = 450
* CHECK dout0_7 vdout0_7ck44 = 0 time = 450
* CHECK dout0_8 vdout0_8ck44 = 0 time = 450
* CHECK dout0_9 vdout0_9ck44 = 0 time = 450
* CHECK dout0_10 vdout0_10ck44 = 0 time = 450
* CHECK dout0_11 vdout0_11ck44 = 0 time = 450
* CHECK dout0_12 vdout0_12ck44 = 0 time = 450
* CHECK dout0_13 vdout0_13ck44 = 0 time = 450
* CHECK dout0_14 vdout0_14ck44 = 0 time = 450
* CHECK dout0_15 vdout0_15ck44 = 0 time = 450
* CHECK dout0_0 vdout0_0ck46 = 5.0 time = 470
* CHECK dout0_1 vdout0_1ck46 = 5.0 time = 470
* CHECK dout0_2 vdout0_2ck46 = 0 time = 470
* CHECK dout0_3 vdout0_3ck46 = 0 time = 470
* CHECK dout0_4 vdout0_4ck46 = 5.0 time = 470
* CHECK dout0_5 vdout0_5ck46 = 0 time = 470
* CHECK dout0_6 vdout0_6ck46 = 0 time = 470
* CHECK dout0_7 vdout0_7ck46 = 0 time = 470
* CHECK dout0_8 vdout0_8ck46 = 0 time = 470
* CHECK dout0_9 vdout0_9ck46 = 5.0 time = 470
* CHECK dout0_10 vdout0_10ck46 = 5.0 time = 470
* CHECK dout0_11 vdout0_11ck46 = 0 time = 470
* CHECK dout0_12 vdout0_12ck46 = 0 time = 470
* CHECK dout0_13 vdout0_13ck46 = 0 time = 470
* CHECK dout0_14 vdout0_14ck46 = 5.0 time = 470
* CHECK dout0_15 vdout0_15ck46 = 5.0 time = 470
* CHECK dout0_0 vdout0_0ck47 = 5.0 time = 480
* CHECK dout0_1 vdout0_1ck47 = 5.0 time = 480
* CHECK dout0_2 vdout0_2ck47 = 0 time = 480
* CHECK dout0_3 vdout0_3ck47 = 0 time = 480
* CHECK dout0_4 vdout0_4ck47 = 5.0 time = 480
* CHECK dout0_5 vdout0_5ck47 = 0 time = 480
* CHECK dout0_6 vdout0_6ck47 = 0 time = 480
* CHECK dout0_7 vdout0_7ck47 = 0 time = 480
* CHECK dout0_8 vdout0_8ck47 = 0 time = 480
* CHECK dout0_9 vdout0_9ck47 = 5.0 time = 480
* CHECK dout0_10 vdout0_10ck47 = 5.0 time = 480
* CHECK dout0_11 vdout0_11ck47 = 0 time = 480
* CHECK dout0_12 vdout0_12ck47 = 0 time = 480
* CHECK dout0_13 vdout0_13ck47 = 0 time = 480
* CHECK dout0_14 vdout0_14ck47 = 5.0 time = 480
* CHECK dout0_15 vdout0_15ck47 = 5.0 time = 480
* CHECK dout0_0 vdout0_0ck48 = 5.0 time = 490
* CHECK dout0_1 vdout0_1ck48 = 5.0 time = 490
* CHECK dout0_2 vdout0_2ck48 = 0 time = 490
* CHECK dout0_3 vdout0_3ck48 = 0 time = 490
* CHECK dout0_4 vdout0_4ck48 = 5.0 time = 490
* CHECK dout0_5 vdout0_5ck48 = 0 time = 490
* CHECK dout0_6 vdout0_6ck48 = 0 time = 490
* CHECK dout0_7 vdout0_7ck48 = 0 time = 490
* CHECK dout0_8 vdout0_8ck48 = 0 time = 490
* CHECK dout0_9 vdout0_9ck48 = 5.0 time = 490
* CHECK dout0_10 vdout0_10ck48 = 5.0 time = 490
* CHECK dout0_11 vdout0_11ck48 = 0 time = 490
* CHECK dout0_12 vdout0_12ck48 = 0 time = 490
* CHECK dout0_13 vdout0_13ck48 = 0 time = 490
* CHECK dout0_14 vdout0_14ck48 = 5.0 time = 490
* CHECK dout0_15 vdout0_15ck48 = 5.0 time = 490
* CHECK dout0_0 vdout0_0ck51 = 0 time = 520
* CHECK dout0_1 vdout0_1ck51 = 0 time = 520
* CHECK dout0_2 vdout0_2ck51 = 5.0 time = 520
* CHECK dout0_3 vdout0_3ck51 = 5.0 time = 520
* CHECK dout0_4 vdout0_4ck51 = 0 time = 520
* CHECK dout0_5 vdout0_5ck51 = 0 time = 520
* CHECK dout0_6 vdout0_6ck51 = 5.0 time = 520
* CHECK dout0_7 vdout0_7ck51 = 0 time = 520
* CHECK dout0_8 vdout0_8ck51 = 0 time = 520
* CHECK dout0_9 vdout0_9ck51 = 0 time = 520
* CHECK dout0_10 vdout0_10ck51 = 0 time = 520
* CHECK dout0_11 vdout0_11ck51 = 0 time = 520
* CHECK dout0_12 vdout0_12ck51 = 0 time = 520
* CHECK dout0_13 vdout0_13ck51 = 0 time = 520
* CHECK dout0_14 vdout0_14ck51 = 0 time = 520
* CHECK dout0_15 vdout0_15ck51 = 0 time = 520
* CHECK dout0_0 vdout0_0ck53 = 0 time = 540
* CHECK dout0_1 vdout0_1ck53 = 0 time = 540
* CHECK dout0_2 vdout0_2ck53 = 5.0 time = 540
* CHECK dout0_3 vdout0_3ck53 = 5.0 time = 540
* CHECK dout0_4 vdout0_4ck53 = 0 time = 540
* CHECK dout0_5 vdout0_5ck53 = 0 time = 540
* CHECK dout0_6 vdout0_6ck53 = 5.0 time = 540
* CHECK dout0_7 vdout0_7ck53 = 0 time = 540
* CHECK dout0_8 vdout0_8ck53 = 0 time = 540
* CHECK dout0_9 vdout0_9ck53 = 0 time = 540
* CHECK dout0_10 vdout0_10ck53 = 0 time = 540
* CHECK dout0_11 vdout0_11ck53 = 0 time = 540
* CHECK dout0_12 vdout0_12ck53 = 0 time = 540
* CHECK dout0_13 vdout0_13ck53 = 0 time = 540
* CHECK dout0_14 vdout0_14ck53 = 0 time = 540
* CHECK dout0_15 vdout0_15ck53 = 0 time = 540
* CHECK dout0_0 vdout0_0ck54 = 0 time = 550
* CHECK dout0_1 vdout0_1ck54 = 0 time = 550
* CHECK dout0_2 vdout0_2ck54 = 5.0 time = 550
* CHECK dout0_3 vdout0_3ck54 = 5.0 time = 550
* CHECK dout0_4 vdout0_4ck54 = 0 time = 550
* CHECK dout0_5 vdout0_5ck54 = 0 time = 550
* CHECK dout0_6 vdout0_6ck54 = 5.0 time = 550
* CHECK dout0_7 vdout0_7ck54 = 0 time = 550
* CHECK dout0_8 vdout0_8ck54 = 0 time = 550
* CHECK dout0_9 vdout0_9ck54 = 0 time = 550
* CHECK dout0_10 vdout0_10ck54 = 0 time = 550
* CHECK dout0_11 vdout0_11ck54 = 0 time = 550
* CHECK dout0_12 vdout0_12ck54 = 0 time = 550
* CHECK dout0_13 vdout0_13ck54 = 0 time = 550
* CHECK dout0_14 vdout0_14ck54 = 0 time = 550
* CHECK dout0_15 vdout0_15ck54 = 0 time = 550
* CHECK dout0_0 vdout0_0ck55 = 0 time = 560
* CHECK dout0_1 vdout0_1ck55 = 5.0 time = 560
* CHECK dout0_2 vdout0_2ck55 = 5.0 time = 560
* CHECK dout0_3 vdout0_3ck55 = 0 time = 560
* CHECK dout0_4 vdout0_4ck55 = 5.0 time = 560
* CHECK dout0_5 vdout0_5ck55 = 5.0 time = 560
* CHECK dout0_6 vdout0_6ck55 = 5.0 time = 560
* CHECK dout0_7 vdout0_7ck55 = 5.0 time = 560
* CHECK dout0_8 vdout0_8ck55 = 5.0 time = 560
* CHECK dout0_9 vdout0_9ck55 = 5.0 time = 560
* CHECK dout0_10 vdout0_10ck55 = 5.0 time = 560
* CHECK dout0_11 vdout0_11ck55 = 0 time = 560
* CHECK dout0_12 vdout0_12ck55 = 5.0 time = 560
* CHECK dout0_13 vdout0_13ck55 = 5.0 time = 560
* CHECK dout0_14 vdout0_14ck55 = 0 time = 560
* CHECK dout0_15 vdout0_15ck55 = 5.0 time = 560
* CHECK dout0_0 vdout0_0ck57 = 0 time = 580
* CHECK dout0_1 vdout0_1ck57 = 5.0 time = 580
* CHECK dout0_2 vdout0_2ck57 = 5.0 time = 580
* CHECK dout0_3 vdout0_3ck57 = 0 time = 580
* CHECK dout0_4 vdout0_4ck57 = 5.0 time = 580
* CHECK dout0_5 vdout0_5ck57 = 5.0 time = 580
* CHECK dout0_6 vdout0_6ck57 = 5.0 time = 580
* CHECK dout0_7 vdout0_7ck57 = 5.0 time = 580
* CHECK dout0_8 vdout0_8ck57 = 5.0 time = 580
* CHECK dout0_9 vdout0_9ck57 = 5.0 time = 580
* CHECK dout0_10 vdout0_10ck57 = 5.0 time = 580
* CHECK dout0_11 vdout0_11ck57 = 0 time = 580
* CHECK dout0_12 vdout0_12ck57 = 5.0 time = 580
* CHECK dout0_13 vdout0_13ck57 = 5.0 time = 580
* CHECK dout0_14 vdout0_14ck57 = 0 time = 580
* CHECK dout0_15 vdout0_15ck57 = 5.0 time = 580
* CHECK dout0_0 vdout0_0ck58 = 0 time = 590
* CHECK dout0_1 vdout0_1ck58 = 0 time = 590
* CHECK dout0_2 vdout0_2ck58 = 5.0 time = 590
* CHECK dout0_3 vdout0_3ck58 = 5.0 time = 590
* CHECK dout0_4 vdout0_4ck58 = 0 time = 590
* CHECK dout0_5 vdout0_5ck58 = 0 time = 590
* CHECK dout0_6 vdout0_6ck58 = 5.0 time = 590
* CHECK dout0_7 vdout0_7ck58 = 0 time = 590
* CHECK dout0_8 vdout0_8ck58 = 0 time = 590
* CHECK dout0_9 vdout0_9ck58 = 0 time = 590
* CHECK dout0_10 vdout0_10ck58 = 0 time = 590
* CHECK dout0_11 vdout0_11ck58 = 0 time = 590
* CHECK dout0_12 vdout0_12ck58 = 0 time = 590
* CHECK dout0_13 vdout0_13ck58 = 0 time = 590
* CHECK dout0_14 vdout0_14ck58 = 0 time = 590
* CHECK dout0_15 vdout0_15ck58 = 0 time = 590
* CHECK dout0_0 vdout0_0ck59 = 0 time = 600
* CHECK dout0_1 vdout0_1ck59 = 0 time = 600
* CHECK dout0_2 vdout0_2ck59 = 5.0 time = 600
* CHECK dout0_3 vdout0_3ck59 = 5.0 time = 600
* CHECK dout0_4 vdout0_4ck59 = 0 time = 600
* CHECK dout0_5 vdout0_5ck59 = 0 time = 600
* CHECK dout0_6 vdout0_6ck59 = 5.0 time = 600
* CHECK dout0_7 vdout0_7ck59 = 0 time = 600
* CHECK dout0_8 vdout0_8ck59 = 0 time = 600
* CHECK dout0_9 vdout0_9ck59 = 0 time = 600
* CHECK dout0_10 vdout0_10ck59 = 0 time = 600
* CHECK dout0_11 vdout0_11ck59 = 0 time = 600
* CHECK dout0_12 vdout0_12ck59 = 0 time = 600
* CHECK dout0_13 vdout0_13ck59 = 0 time = 600
* CHECK dout0_14 vdout0_14ck59 = 0 time = 600
* CHECK dout0_15 vdout0_15ck59 = 0 time = 600
* CHECK dout0_0 vdout0_0ck60 = 0 time = 610
* CHECK dout0_1 vdout0_1ck60 = 0 time = 610
* CHECK dout0_2 vdout0_2ck60 = 5.0 time = 610
* CHECK dout0_3 vdout0_3ck60 = 5.0 time = 610
* CHECK dout0_4 vdout0_4ck60 = 0 time = 610
* CHECK dout0_5 vdout0_5ck60 = 0 time = 610
* CHECK dout0_6 vdout0_6ck60 = 5.0 time = 610
* CHECK dout0_7 vdout0_7ck60 = 0 time = 610
* CHECK dout0_8 vdout0_8ck60 = 0 time = 610
* CHECK dout0_9 vdout0_9ck60 = 0 time = 610
* CHECK dout0_10 vdout0_10ck60 = 0 time = 610
* CHECK dout0_11 vdout0_11ck60 = 0 time = 610
* CHECK dout0_12 vdout0_12ck60 = 0 time = 610
* CHECK dout0_13 vdout0_13ck60 = 0 time = 610
* CHECK dout0_14 vdout0_14ck60 = 0 time = 610
* CHECK dout0_15 vdout0_15ck60 = 0 time = 610
* CHECK dout0_0 vdout0_0ck61 = 0 time = 620
* CHECK dout0_1 vdout0_1ck61 = 5.0 time = 620
* CHECK dout0_2 vdout0_2ck61 = 5.0 time = 620
* CHECK dout0_3 vdout0_3ck61 = 0 time = 620
* CHECK dout0_4 vdout0_4ck61 = 5.0 time = 620
* CHECK dout0_5 vdout0_5ck61 = 5.0 time = 620
* CHECK dout0_6 vdout0_6ck61 = 5.0 time = 620
* CHECK dout0_7 vdout0_7ck61 = 5.0 time = 620
* CHECK dout0_8 vdout0_8ck61 = 5.0 time = 620
* CHECK dout0_9 vdout0_9ck61 = 5.0 time = 620
* CHECK dout0_10 vdout0_10ck61 = 5.0 time = 620
* CHECK dout0_11 vdout0_11ck61 = 0 time = 620
* CHECK dout0_12 vdout0_12ck61 = 5.0 time = 620
* CHECK dout0_13 vdout0_13ck61 = 5.0 time = 620
* CHECK dout0_14 vdout0_14ck61 = 0 time = 620
* CHECK dout0_15 vdout0_15ck61 = 5.0 time = 620
* CHECK dout0_0 vdout0_0ck66 = 0 time = 670
* CHECK dout0_1 vdout0_1ck66 = 5.0 time = 670
* CHECK dout0_2 vdout0_2ck66 = 5.0 time = 670
* CHECK dout0_3 vdout0_3ck66 = 0 time = 670
* CHECK dout0_4 vdout0_4ck66 = 5.0 time = 670
* CHECK dout0_5 vdout0_5ck66 = 5.0 time = 670
* CHECK dout0_6 vdout0_6ck66 = 5.0 time = 670
* CHECK dout0_7 vdout0_7ck66 = 5.0 time = 670
* CHECK dout0_8 vdout0_8ck66 = 5.0 time = 670
* CHECK dout0_9 vdout0_9ck66 = 5.0 time = 670
* CHECK dout0_10 vdout0_10ck66 = 5.0 time = 670
* CHECK dout0_11 vdout0_11ck66 = 0 time = 670
* CHECK dout0_12 vdout0_12ck66 = 5.0 time = 670
* CHECK dout0_13 vdout0_13ck66 = 5.0 time = 670
* CHECK dout0_14 vdout0_14ck66 = 0 time = 670
* CHECK dout0_15 vdout0_15ck66 = 5.0 time = 670
* CHECK dout0_0 vdout0_0ck67 = 0 time = 680
* CHECK dout0_1 vdout0_1ck67 = 5.0 time = 680
* CHECK dout0_2 vdout0_2ck67 = 5.0 time = 680
* CHECK dout0_3 vdout0_3ck67 = 0 time = 680
* CHECK dout0_4 vdout0_4ck67 = 5.0 time = 680
* CHECK dout0_5 vdout0_5ck67 = 5.0 time = 680
* CHECK dout0_6 vdout0_6ck67 = 5.0 time = 680
* CHECK dout0_7 vdout0_7ck67 = 5.0 time = 680
* CHECK dout0_8 vdout0_8ck67 = 5.0 time = 680
* CHECK dout0_9 vdout0_9ck67 = 5.0 time = 680
* CHECK dout0_10 vdout0_10ck67 = 5.0 time = 680
* CHECK dout0_11 vdout0_11ck67 = 0 time = 680
* CHECK dout0_12 vdout0_12ck67 = 5.0 time = 680
* CHECK dout0_13 vdout0_13ck67 = 5.0 time = 680
* CHECK dout0_14 vdout0_14ck67 = 0 time = 680
* CHECK dout0_15 vdout0_15ck67 = 5.0 time = 680
* CHECK dout0_0 vdout0_0ck69 = 0 time = 700
* CHECK dout0_1 vdout0_1ck69 = 5.0 time = 700
* CHECK dout0_2 vdout0_2ck69 = 5.0 time = 700
* CHECK dout0_3 vdout0_3ck69 = 0 time = 700
* CHECK dout0_4 vdout0_4ck69 = 5.0 time = 700
* CHECK dout0_5 vdout0_5ck69 = 5.0 time = 700
* CHECK dout0_6 vdout0_6ck69 = 5.0 time = 700
* CHECK dout0_7 vdout0_7ck69 = 5.0 time = 700
* CHECK dout0_8 vdout0_8ck69 = 5.0 time = 700
* CHECK dout0_9 vdout0_9ck69 = 5.0 time = 700
* CHECK dout0_10 vdout0_10ck69 = 5.0 time = 700
* CHECK dout0_11 vdout0_11ck69 = 0 time = 700
* CHECK dout0_12 vdout0_12ck69 = 5.0 time = 700
* CHECK dout0_13 vdout0_13ck69 = 5.0 time = 700
* CHECK dout0_14 vdout0_14ck69 = 0 time = 700
* CHECK dout0_15 vdout0_15ck69 = 5.0 time = 700
* CHECK dout0_0 vdout0_0ck71 = 5.0 time = 720
* CHECK dout0_1 vdout0_1ck71 = 5.0 time = 720
* CHECK dout0_2 vdout0_2ck71 = 0 time = 720
* CHECK dout0_3 vdout0_3ck71 = 5.0 time = 720
* CHECK dout0_4 vdout0_4ck71 = 5.0 time = 720
* CHECK dout0_5 vdout0_5ck71 = 5.0 time = 720
* CHECK dout0_6 vdout0_6ck71 = 0 time = 720
* CHECK dout0_7 vdout0_7ck71 = 5.0 time = 720
* CHECK dout0_8 vdout0_8ck71 = 5.0 time = 720
* CHECK dout0_9 vdout0_9ck71 = 5.0 time = 720
* CHECK dout0_10 vdout0_10ck71 = 0 time = 720
* CHECK dout0_11 vdout0_11ck71 = 5.0 time = 720
* CHECK dout0_12 vdout0_12ck71 = 0 time = 720
* CHECK dout0_13 vdout0_13ck71 = 0 time = 720
* CHECK dout0_14 vdout0_14ck71 = 5.0 time = 720
* CHECK dout0_15 vdout0_15ck71 = 5.0 time = 720
* CHECK dout0_0 vdout0_0ck72 = 0 time = 730
* CHECK dout0_1 vdout0_1ck72 = 0 time = 730
* CHECK dout0_2 vdout0_2ck72 = 0 time = 730
* CHECK dout0_3 vdout0_3ck72 = 5.0 time = 730
* CHECK dout0_4 vdout0_4ck72 = 5.0 time = 730
* CHECK dout0_5 vdout0_5ck72 = 5.0 time = 730
* CHECK dout0_6 vdout0_6ck72 = 5.0 time = 730
* CHECK dout0_7 vdout0_7ck72 = 0 time = 730
* CHECK dout0_8 vdout0_8ck72 = 5.0 time = 730
* CHECK dout0_9 vdout0_9ck72 = 5.0 time = 730
* CHECK dout0_10 vdout0_10ck72 = 0 time = 730
* CHECK dout0_11 vdout0_11ck72 = 5.0 time = 730
* CHECK dout0_12 vdout0_12ck72 = 5.0 time = 730
* CHECK dout0_13 vdout0_13ck72 = 0 time = 730
* CHECK dout0_14 vdout0_14ck72 = 5.0 time = 730
* CHECK dout0_15 vdout0_15ck72 = 5.0 time = 730
* CHECK dout0_0 vdout0_0ck73 = 0 time = 740
* CHECK dout0_1 vdout0_1ck73 = 0 time = 740
* CHECK dout0_2 vdout0_2ck73 = 0 time = 740
* CHECK dout0_3 vdout0_3ck73 = 5.0 time = 740
* CHECK dout0_4 vdout0_4ck73 = 5.0 time = 740
* CHECK dout0_5 vdout0_5ck73 = 5.0 time = 740
* CHECK dout0_6 vdout0_6ck73 = 5.0 time = 740
* CHECK dout0_7 vdout0_7ck73 = 0 time = 740
* CHECK dout0_8 vdout0_8ck73 = 5.0 time = 740
* CHECK dout0_9 vdout0_9ck73 = 5.0 time = 740
* CHECK dout0_10 vdout0_10ck73 = 0 time = 740
* CHECK dout0_11 vdout0_11ck73 = 5.0 time = 740
* CHECK dout0_12 vdout0_12ck73 = 5.0 time = 740
* CHECK dout0_13 vdout0_13ck73 = 0 time = 740
* CHECK dout0_14 vdout0_14ck73 = 5.0 time = 740
* CHECK dout0_15 vdout0_15ck73 = 5.0 time = 740
* CHECK dout0_0 vdout0_0ck74 = 5.0 time = 750
* CHECK dout0_1 vdout0_1ck74 = 5.0 time = 750
* CHECK dout0_2 vdout0_2ck74 = 0 time = 750
* CHECK dout0_3 vdout0_3ck74 = 5.0 time = 750
* CHECK dout0_4 vdout0_4ck74 = 5.0 time = 750
* CHECK dout0_5 vdout0_5ck74 = 5.0 time = 750
* CHECK dout0_6 vdout0_6ck74 = 0 time = 750
* CHECK dout0_7 vdout0_7ck74 = 5.0 time = 750
* CHECK dout0_8 vdout0_8ck74 = 5.0 time = 750
* CHECK dout0_9 vdout0_9ck74 = 5.0 time = 750
* CHECK dout0_10 vdout0_10ck74 = 0 time = 750
* CHECK dout0_11 vdout0_11ck74 = 5.0 time = 750
* CHECK dout0_12 vdout0_12ck74 = 0 time = 750
* CHECK dout0_13 vdout0_13ck74 = 0 time = 750
* CHECK dout0_14 vdout0_14ck74 = 5.0 time = 750
* CHECK dout0_15 vdout0_15ck74 = 5.0 time = 750
* CHECK dout0_0 vdout0_0ck77 = 5.0 time = 780
* CHECK dout0_1 vdout0_1ck77 = 0 time = 780
* CHECK dout0_2 vdout0_2ck77 = 0 time = 780
* CHECK dout0_3 vdout0_3ck77 = 5.0 time = 780
* CHECK dout0_4 vdout0_4ck77 = 0 time = 780
* CHECK dout0_5 vdout0_5ck77 = 0 time = 780
* CHECK dout0_6 vdout0_6ck77 = 0 time = 780
* CHECK dout0_7 vdout0_7ck77 = 0 time = 780
* CHECK dout0_8 vdout0_8ck77 = 5.0 time = 780
* CHECK dout0_9 vdout0_9ck77 = 0 time = 780
* CHECK dout0_10 vdout0_10ck77 = 0 time = 780
* CHECK dout0_11 vdout0_11ck77 = 0 time = 780
* CHECK dout0_12 vdout0_12ck77 = 0 time = 780
* CHECK dout0_13 vdout0_13ck77 = 5.0 time = 780
* CHECK dout0_14 vdout0_14ck77 = 5.0 time = 780
* CHECK dout0_15 vdout0_15ck77 = 5.0 time = 780
* CHECK dout0_0 vdout0_0ck80 = 5.0 time = 810
* CHECK dout0_1 vdout0_1ck80 = 0 time = 810
* CHECK dout0_2 vdout0_2ck80 = 0 time = 810
* CHECK dout0_3 vdout0_3ck80 = 5.0 time = 810
* CHECK dout0_4 vdout0_4ck80 = 0 time = 810
* CHECK dout0_5 vdout0_5ck80 = 0 time = 810
* CHECK dout0_6 vdout0_6ck80 = 0 time = 810
* CHECK dout0_7 vdout0_7ck80 = 0 time = 810
* CHECK dout0_8 vdout0_8ck80 = 5.0 time = 810
* CHECK dout0_9 vdout0_9ck80 = 0 time = 810
* CHECK dout0_10 vdout0_10ck80 = 0 time = 810
* CHECK dout0_11 vdout0_11ck80 = 0 time = 810
* CHECK dout0_12 vdout0_12ck80 = 0 time = 810
* CHECK dout0_13 vdout0_13ck80 = 5.0 time = 810
* CHECK dout0_14 vdout0_14ck80 = 5.0 time = 810
* CHECK dout0_15 vdout0_15ck80 = 5.0 time = 810
* CHECK dout0_0 vdout0_0ck81 = 5.0 time = 820
* CHECK dout0_1 vdout0_1ck81 = 5.0 time = 820
* CHECK dout0_2 vdout0_2ck81 = 0 time = 820
* CHECK dout0_3 vdout0_3ck81 = 5.0 time = 820
* CHECK dout0_4 vdout0_4ck81 = 5.0 time = 820
* CHECK dout0_5 vdout0_5ck81 = 5.0 time = 820
* CHECK dout0_6 vdout0_6ck81 = 0 time = 820
* CHECK dout0_7 vdout0_7ck81 = 5.0 time = 820
* CHECK dout0_8 vdout0_8ck81 = 5.0 time = 820
* CHECK dout0_9 vdout0_9ck81 = 5.0 time = 820
* CHECK dout0_10 vdout0_10ck81 = 0 time = 820
* CHECK dout0_11 vdout0_11ck81 = 5.0 time = 820
* CHECK dout0_12 vdout0_12ck81 = 0 time = 820
* CHECK dout0_13 vdout0_13ck81 = 0 time = 820
* CHECK dout0_14 vdout0_14ck81 = 5.0 time = 820
* CHECK dout0_15 vdout0_15ck81 = 5.0 time = 820
* CHECK dout0_0 vdout0_0ck82 = 5.0 time = 830
* CHECK dout0_1 vdout0_1ck82 = 0 time = 830
* CHECK dout0_2 vdout0_2ck82 = 0 time = 830
* CHECK dout0_3 vdout0_3ck82 = 5.0 time = 830
* CHECK dout0_4 vdout0_4ck82 = 0 time = 830
* CHECK dout0_5 vdout0_5ck82 = 0 time = 830
* CHECK dout0_6 vdout0_6ck82 = 0 time = 830
* CHECK dout0_7 vdout0_7ck82 = 0 time = 830
* CHECK dout0_8 vdout0_8ck82 = 5.0 time = 830
* CHECK dout0_9 vdout0_9ck82 = 0 time = 830
* CHECK dout0_10 vdout0_10ck82 = 0 time = 830
* CHECK dout0_11 vdout0_11ck82 = 0 time = 830
* CHECK dout0_12 vdout0_12ck82 = 0 time = 830
* CHECK dout0_13 vdout0_13ck82 = 5.0 time = 830
* CHECK dout0_14 vdout0_14ck82 = 5.0 time = 830
* CHECK dout0_15 vdout0_15ck82 = 5.0 time = 830
* CHECK dout0_0 vdout0_0ck83 = 5.0 time = 840
* CHECK dout0_1 vdout0_1ck83 = 5.0 time = 840
* CHECK dout0_2 vdout0_2ck83 = 0 time = 840
* CHECK dout0_3 vdout0_3ck83 = 5.0 time = 840
* CHECK dout0_4 vdout0_4ck83 = 5.0 time = 840
* CHECK dout0_5 vdout0_5ck83 = 5.0 time = 840
* CHECK dout0_6 vdout0_6ck83 = 0 time = 840
* CHECK dout0_7 vdout0_7ck83 = 5.0 time = 840
* CHECK dout0_8 vdout0_8ck83 = 5.0 time = 840
* CHECK dout0_9 vdout0_9ck83 = 5.0 time = 840
* CHECK dout0_10 vdout0_10ck83 = 0 time = 840
* CHECK dout0_11 vdout0_11ck83 = 5.0 time = 840
* CHECK dout0_12 vdout0_12ck83 = 0 time = 840
* CHECK dout0_13 vdout0_13ck83 = 0 time = 840
* CHECK dout0_14 vdout0_14ck83 = 5.0 time = 840
* CHECK dout0_15 vdout0_15ck83 = 5.0 time = 840
* CHECK dout0_0 vdout0_0ck85 = 5.0 time = 860
* CHECK dout0_1 vdout0_1ck85 = 0 time = 860
* CHECK dout0_2 vdout0_2ck85 = 0 time = 860
* CHECK dout0_3 vdout0_3ck85 = 5.0 time = 860
* CHECK dout0_4 vdout0_4ck85 = 0 time = 860
* CHECK dout0_5 vdout0_5ck85 = 0 time = 860
* CHECK dout0_6 vdout0_6ck85 = 0 time = 860
* CHECK dout0_7 vdout0_7ck85 = 0 time = 860
* CHECK dout0_8 vdout0_8ck85 = 5.0 time = 860
* CHECK dout0_9 vdout0_9ck85 = 0 time = 860
* CHECK dout0_10 vdout0_10ck85 = 0 time = 860
* CHECK dout0_11 vdout0_11ck85 = 0 time = 860
* CHECK dout0_12 vdout0_12ck85 = 0 time = 860
* CHECK dout0_13 vdout0_13ck85 = 5.0 time = 860
* CHECK dout0_14 vdout0_14ck85 = 5.0 time = 860
* CHECK dout0_15 vdout0_15ck85 = 5.0 time = 860
* CHECK dout0_0 vdout0_0ck86 = 5.0 time = 870
* CHECK dout0_1 vdout0_1ck86 = 0 time = 870
* CHECK dout0_2 vdout0_2ck86 = 0 time = 870
* CHECK dout0_3 vdout0_3ck86 = 5.0 time = 870
* CHECK dout0_4 vdout0_4ck86 = 0 time = 870
* CHECK dout0_5 vdout0_5ck86 = 0 time = 870
* CHECK dout0_6 vdout0_6ck86 = 0 time = 870
* CHECK dout0_7 vdout0_7ck86 = 0 time = 870
* CHECK dout0_8 vdout0_8ck86 = 5.0 time = 870
* CHECK dout0_9 vdout0_9ck86 = 0 time = 870
* CHECK dout0_10 vdout0_10ck86 = 0 time = 870
* CHECK dout0_11 vdout0_11ck86 = 0 time = 870
* CHECK dout0_12 vdout0_12ck86 = 0 time = 870
* CHECK dout0_13 vdout0_13ck86 = 5.0 time = 870
* CHECK dout0_14 vdout0_14ck86 = 5.0 time = 870
* CHECK dout0_15 vdout0_15ck86 = 5.0 time = 870
* CHECK dout0_0 vdout0_0ck87 = 5.0 time = 880
* CHECK dout0_1 vdout0_1ck87 = 0 time = 880
* CHECK dout0_2 vdout0_2ck87 = 0 time = 880
* CHECK dout0_3 vdout0_3ck87 = 5.0 time = 880
* CHECK dout0_4 vdout0_4ck87 = 0 time = 880
* CHECK dout0_5 vdout0_5ck87 = 0 time = 880
* CHECK dout0_6 vdout0_6ck87 = 0 time = 880
* CHECK dout0_7 vdout0_7ck87 = 0 time = 880
* CHECK dout0_8 vdout0_8ck87 = 5.0 time = 880
* CHECK dout0_9 vdout0_9ck87 = 0 time = 880
* CHECK dout0_10 vdout0_10ck87 = 0 time = 880
* CHECK dout0_11 vdout0_11ck87 = 0 time = 880
* CHECK dout0_12 vdout0_12ck87 = 0 time = 880
* CHECK dout0_13 vdout0_13ck87 = 5.0 time = 880
* CHECK dout0_14 vdout0_14ck87 = 5.0 time = 880
* CHECK dout0_15 vdout0_15ck87 = 5.0 time = 880
* CHECK dout0_0 vdout0_0ck89 = 5.0 time = 900
* CHECK dout0_1 vdout0_1ck89 = 0 time = 900
* CHECK dout0_2 vdout0_2ck89 = 0 time = 900
* CHECK dout0_3 vdout0_3ck89 = 5.0 time = 900
* CHECK dout0_4 vdout0_4ck89 = 0 time = 900
* CHECK dout0_5 vdout0_5ck89 = 0 time = 900
* CHECK dout0_6 vdout0_6ck89 = 0 time = 900
* CHECK dout0_7 vdout0_7ck89 = 0 time = 900
* CHECK dout0_8 vdout0_8ck89 = 5.0 time = 900
* CHECK dout0_9 vdout0_9ck89 = 0 time = 900
* CHECK dout0_10 vdout0_10ck89 = 0 time = 900
* CHECK dout0_11 vdout0_11ck89 = 0 time = 900
* CHECK dout0_12 vdout0_12ck89 = 0 time = 900
* CHECK dout0_13 vdout0_13ck89 = 5.0 time = 900
* CHECK dout0_14 vdout0_14ck89 = 5.0 time = 900
* CHECK dout0_15 vdout0_15ck89 = 5.0 time = 900
* CHECK dout0_0 vdout0_0ck91 = 0 time = 920
* CHECK dout0_1 vdout0_1ck91 = 0 time = 920
* CHECK dout0_2 vdout0_2ck91 = 5.0 time = 920
* CHECK dout0_3 vdout0_3ck91 = 0 time = 920
* CHECK dout0_4 vdout0_4ck91 = 5.0 time = 920
* CHECK dout0_5 vdout0_5ck91 = 5.0 time = 920
* CHECK dout0_6 vdout0_6ck91 = 0 time = 920
* CHECK dout0_7 vdout0_7ck91 = 5.0 time = 920
* CHECK dout0_8 vdout0_8ck91 = 5.0 time = 920
* CHECK dout0_9 vdout0_9ck91 = 5.0 time = 920
* CHECK dout0_10 vdout0_10ck91 = 5.0 time = 920
* CHECK dout0_11 vdout0_11ck91 = 0 time = 920
* CHECK dout0_12 vdout0_12ck91 = 0 time = 920
* CHECK dout0_13 vdout0_13ck91 = 0 time = 920
* CHECK dout0_14 vdout0_14ck91 = 5.0 time = 920
* CHECK dout0_15 vdout0_15ck91 = 0 time = 920
* CHECK dout0_0 vdout0_0ck92 = 0 time = 930
* CHECK dout0_1 vdout0_1ck92 = 0 time = 930
* CHECK dout0_2 vdout0_2ck92 = 5.0 time = 930
* CHECK dout0_3 vdout0_3ck92 = 0 time = 930
* CHECK dout0_4 vdout0_4ck92 = 5.0 time = 930
* CHECK dout0_5 vdout0_5ck92 = 5.0 time = 930
* CHECK dout0_6 vdout0_6ck92 = 0 time = 930
* CHECK dout0_7 vdout0_7ck92 = 5.0 time = 930
* CHECK dout0_8 vdout0_8ck92 = 5.0 time = 930
* CHECK dout0_9 vdout0_9ck92 = 5.0 time = 930
* CHECK dout0_10 vdout0_10ck92 = 5.0 time = 930
* CHECK dout0_11 vdout0_11ck92 = 0 time = 930
* CHECK dout0_12 vdout0_12ck92 = 0 time = 930
* CHECK dout0_13 vdout0_13ck92 = 0 time = 930
* CHECK dout0_14 vdout0_14ck92 = 5.0 time = 930
* CHECK dout0_15 vdout0_15ck92 = 0 time = 930
* CHECK dout0_0 vdout0_0ck93 = 5.0 time = 940
* CHECK dout0_1 vdout0_1ck93 = 0 time = 940
* CHECK dout0_2 vdout0_2ck93 = 0 time = 940
* CHECK dout0_3 vdout0_3ck93 = 5.0 time = 940
* CHECK dout0_4 vdout0_4ck93 = 0 time = 940
* CHECK dout0_5 vdout0_5ck93 = 0 time = 940
* CHECK dout0_6 vdout0_6ck93 = 0 time = 940
* CHECK dout0_7 vdout0_7ck93 = 0 time = 940
* CHECK dout0_8 vdout0_8ck93 = 5.0 time = 940
* CHECK dout0_9 vdout0_9ck93 = 0 time = 940
* CHECK dout0_10 vdout0_10ck93 = 0 time = 940
* CHECK dout0_11 vdout0_11ck93 = 0 time = 940
* CHECK dout0_12 vdout0_12ck93 = 0 time = 940
* CHECK dout0_13 vdout0_13ck93 = 5.0 time = 940
* CHECK dout0_14 vdout0_14ck93 = 5.0 time = 940
* CHECK dout0_15 vdout0_15ck93 = 5.0 time = 940
* CHECK dout0_0 vdout0_0ck96 = 5.0 time = 970
* CHECK dout0_1 vdout0_1ck96 = 0 time = 970
* CHECK dout0_2 vdout0_2ck96 = 0 time = 970
* CHECK dout0_3 vdout0_3ck96 = 0 time = 970
* CHECK dout0_4 vdout0_4ck96 = 5.0 time = 970
* CHECK dout0_5 vdout0_5ck96 = 5.0 time = 970
* CHECK dout0_6 vdout0_6ck96 = 5.0 time = 970
* CHECK dout0_7 vdout0_7ck96 = 0 time = 970
* CHECK dout0_8 vdout0_8ck96 = 5.0 time = 970
* CHECK dout0_9 vdout0_9ck96 = 0 time = 970
* CHECK dout0_10 vdout0_10ck96 = 0 time = 970
* CHECK dout0_11 vdout0_11ck96 = 0 time = 970
* CHECK dout0_12 vdout0_12ck96 = 5.0 time = 970
* CHECK dout0_13 vdout0_13ck96 = 5.0 time = 970
* CHECK dout0_14 vdout0_14ck96 = 5.0 time = 970
* CHECK dout0_15 vdout0_15ck96 = 0 time = 970
* CHECK dout0_0 vdout0_0ck97 = 5.0 time = 980
* CHECK dout0_1 vdout0_1ck97 = 0 time = 980
* CHECK dout0_2 vdout0_2ck97 = 0 time = 980
* CHECK dout0_3 vdout0_3ck97 = 5.0 time = 980
* CHECK dout0_4 vdout0_4ck97 = 0 time = 980
* CHECK dout0_5 vdout0_5ck97 = 0 time = 980
* CHECK dout0_6 vdout0_6ck97 = 0 time = 980
* CHECK dout0_7 vdout0_7ck97 = 0 time = 980
* CHECK dout0_8 vdout0_8ck97 = 5.0 time = 980
* CHECK dout0_9 vdout0_9ck97 = 0 time = 980
* CHECK dout0_10 vdout0_10ck97 = 0 time = 980
* CHECK dout0_11 vdout0_11ck97 = 0 time = 980
* CHECK dout0_12 vdout0_12ck97 = 0 time = 980
* CHECK dout0_13 vdout0_13ck97 = 5.0 time = 980
* CHECK dout0_14 vdout0_14ck97 = 5.0 time = 980
* CHECK dout0_15 vdout0_15ck97 = 5.0 time = 980
* CHECK dout0_0 vdout0_0ck98 = 5.0 time = 990
* CHECK dout0_1 vdout0_1ck98 = 0 time = 990
* CHECK dout0_2 vdout0_2ck98 = 0 time = 990
* CHECK dout0_3 vdout0_3ck98 = 0 time = 990
* CHECK dout0_4 vdout0_4ck98 = 5.0 time = 990
* CHECK dout0_5 vdout0_5ck98 = 5.0 time = 990
* CHECK dout0_6 vdout0_6ck98 = 5.0 time = 990
* CHECK dout0_7 vdout0_7ck98 = 0 time = 990
* CHECK dout0_8 vdout0_8ck98 = 5.0 time = 990
* CHECK dout0_9 vdout0_9ck98 = 0 time = 990
* CHECK dout0_10 vdout0_10ck98 = 0 time = 990
* CHECK dout0_11 vdout0_11ck98 = 0 time = 990
* CHECK dout0_12 vdout0_12ck98 = 5.0 time = 990
* CHECK dout0_13 vdout0_13ck98 = 5.0 time = 990
* CHECK dout0_14 vdout0_14ck98 = 5.0 time = 990
* CHECK dout0_15 vdout0_15ck98 = 0 time = 990
* CHECK dout0_0 vdout0_0ck100 = 5.0 time = 1010
* CHECK dout0_1 vdout0_1ck100 = 0 time = 1010
* CHECK dout0_2 vdout0_2ck100 = 0 time = 1010
* CHECK dout0_3 vdout0_3ck100 = 0 time = 1010
* CHECK dout0_4 vdout0_4ck100 = 5.0 time = 1010
* CHECK dout0_5 vdout0_5ck100 = 5.0 time = 1010
* CHECK dout0_6 vdout0_6ck100 = 5.0 time = 1010
* CHECK dout0_7 vdout0_7ck100 = 0 time = 1010
* CHECK dout0_8 vdout0_8ck100 = 5.0 time = 1010
* CHECK dout0_9 vdout0_9ck100 = 0 time = 1010
* CHECK dout0_10 vdout0_10ck100 = 0 time = 1010
* CHECK dout0_11 vdout0_11ck100 = 0 time = 1010
* CHECK dout0_12 vdout0_12ck100 = 5.0 time = 1010
* CHECK dout0_13 vdout0_13ck100 = 5.0 time = 1010
* CHECK dout0_14 vdout0_14ck100 = 5.0 time = 1010
* CHECK dout0_15 vdout0_15ck100 = 0 time = 1010
* CHECK dout0_0 vdout0_0ck101 = 5.0 time = 1020
* CHECK dout0_1 vdout0_1ck101 = 0 time = 1020
* CHECK dout0_2 vdout0_2ck101 = 0 time = 1020
* CHECK dout0_3 vdout0_3ck101 = 0 time = 1020
* CHECK dout0_4 vdout0_4ck101 = 0 time = 1020
* CHECK dout0_5 vdout0_5ck101 = 0 time = 1020
* CHECK dout0_6 vdout0_6ck101 = 5.0 time = 1020
* CHECK dout0_7 vdout0_7ck101 = 5.0 time = 1020
* CHECK dout0_8 vdout0_8ck101 = 0 time = 1020
* CHECK dout0_9 vdout0_9ck101 = 0 time = 1020
* CHECK dout0_10 vdout0_10ck101 = 5.0 time = 1020
* CHECK dout0_11 vdout0_11ck101 = 5.0 time = 1020
* CHECK dout0_12 vdout0_12ck101 = 0 time = 1020
* CHECK dout0_13 vdout0_13ck101 = 0 time = 1020
* CHECK dout0_14 vdout0_14ck101 = 5.0 time = 1020
* CHECK dout0_15 vdout0_15ck101 = 0 time = 1020
* CHECK dout0_0 vdout0_0ck102 = 5.0 time = 1030
* CHECK dout0_1 vdout0_1ck102 = 0 time = 1030
* CHECK dout0_2 vdout0_2ck102 = 0 time = 1030
* CHECK dout0_3 vdout0_3ck102 = 0 time = 1030
* CHECK dout0_4 vdout0_4ck102 = 5.0 time = 1030
* CHECK dout0_5 vdout0_5ck102 = 5.0 time = 1030
* CHECK dout0_6 vdout0_6ck102 = 5.0 time = 1030
* CHECK dout0_7 vdout0_7ck102 = 0 time = 1030
* CHECK dout0_8 vdout0_8ck102 = 5.0 time = 1030
* CHECK dout0_9 vdout0_9ck102 = 0 time = 1030
* CHECK dout0_10 vdout0_10ck102 = 0 time = 1030
* CHECK dout0_11 vdout0_11ck102 = 0 time = 1030
* CHECK dout0_12 vdout0_12ck102 = 5.0 time = 1030
* CHECK dout0_13 vdout0_13ck102 = 5.0 time = 1030
* CHECK dout0_14 vdout0_14ck102 = 5.0 time = 1030
* CHECK dout0_15 vdout0_15ck102 = 0 time = 1030
* CHECK dout0_0 vdout0_0ck106 = 5.0 time = 1070
* CHECK dout0_1 vdout0_1ck106 = 0 time = 1070
* CHECK dout0_2 vdout0_2ck106 = 0 time = 1070
* CHECK dout0_3 vdout0_3ck106 = 0 time = 1070
* CHECK dout0_4 vdout0_4ck106 = 5.0 time = 1070
* CHECK dout0_5 vdout0_5ck106 = 5.0 time = 1070
* CHECK dout0_6 vdout0_6ck106 = 5.0 time = 1070
* CHECK dout0_7 vdout0_7ck106 = 0 time = 1070
* CHECK dout0_8 vdout0_8ck106 = 5.0 time = 1070
* CHECK dout0_9 vdout0_9ck106 = 0 time = 1070
* CHECK dout0_10 vdout0_10ck106 = 0 time = 1070
* CHECK dout0_11 vdout0_11ck106 = 0 time = 1070
* CHECK dout0_12 vdout0_12ck106 = 5.0 time = 1070
* CHECK dout0_13 vdout0_13ck106 = 5.0 time = 1070
* CHECK dout0_14 vdout0_14ck106 = 5.0 time = 1070
* CHECK dout0_15 vdout0_15ck106 = 0 time = 1070
* CHECK dout0_0 vdout0_0ck108 = 0 time = 1090
* CHECK dout0_1 vdout0_1ck108 = 5.0 time = 1090
* CHECK dout0_2 vdout0_2ck108 = 0 time = 1090
* CHECK dout0_3 vdout0_3ck108 = 5.0 time = 1090
* CHECK dout0_4 vdout0_4ck108 = 0 time = 1090
* CHECK dout0_5 vdout0_5ck108 = 5.0 time = 1090
* CHECK dout0_6 vdout0_6ck108 = 0 time = 1090
* CHECK dout0_7 vdout0_7ck108 = 5.0 time = 1090
* CHECK dout0_8 vdout0_8ck108 = 0 time = 1090
* CHECK dout0_9 vdout0_9ck108 = 0 time = 1090
* CHECK dout0_10 vdout0_10ck108 = 5.0 time = 1090
* CHECK dout0_11 vdout0_11ck108 = 0 time = 1090
* CHECK dout0_12 vdout0_12ck108 = 0 time = 1090
* CHECK dout0_13 vdout0_13ck108 = 5.0 time = 1090
* CHECK dout0_14 vdout0_14ck108 = 5.0 time = 1090
* CHECK dout0_15 vdout0_15ck108 = 0 time = 1090
* CHECK dout0_0 vdout0_0ck110 = 5.0 time = 1110
* CHECK dout0_1 vdout0_1ck110 = 0 time = 1110
* CHECK dout0_2 vdout0_2ck110 = 0 time = 1110
* CHECK dout0_3 vdout0_3ck110 = 0 time = 1110
* CHECK dout0_4 vdout0_4ck110 = 5.0 time = 1110
* CHECK dout0_5 vdout0_5ck110 = 5.0 time = 1110
* CHECK dout0_6 vdout0_6ck110 = 5.0 time = 1110
* CHECK dout0_7 vdout0_7ck110 = 0 time = 1110
* CHECK dout0_8 vdout0_8ck110 = 5.0 time = 1110
* CHECK dout0_9 vdout0_9ck110 = 0 time = 1110
* CHECK dout0_10 vdout0_10ck110 = 0 time = 1110
* CHECK dout0_11 vdout0_11ck110 = 0 time = 1110
* CHECK dout0_12 vdout0_12ck110 = 5.0 time = 1110
* CHECK dout0_13 vdout0_13ck110 = 5.0 time = 1110
* CHECK dout0_14 vdout0_14ck110 = 5.0 time = 1110
* CHECK dout0_15 vdout0_15ck110 = 0 time = 1110
* CHECK dout0_0 vdout0_0ck111 = 5.0 time = 1120
* CHECK dout0_1 vdout0_1ck111 = 0 time = 1120
* CHECK dout0_2 vdout0_2ck111 = 0 time = 1120
* CHECK dout0_3 vdout0_3ck111 = 0 time = 1120
* CHECK dout0_4 vdout0_4ck111 = 5.0 time = 1120
* CHECK dout0_5 vdout0_5ck111 = 5.0 time = 1120
* CHECK dout0_6 vdout0_6ck111 = 5.0 time = 1120
* CHECK dout0_7 vdout0_7ck111 = 0 time = 1120
* CHECK dout0_8 vdout0_8ck111 = 5.0 time = 1120
* CHECK dout0_9 vdout0_9ck111 = 0 time = 1120
* CHECK dout0_10 vdout0_10ck111 = 0 time = 1120
* CHECK dout0_11 vdout0_11ck111 = 0 time = 1120
* CHECK dout0_12 vdout0_12ck111 = 5.0 time = 1120
* CHECK dout0_13 vdout0_13ck111 = 5.0 time = 1120
* CHECK dout0_14 vdout0_14ck111 = 5.0 time = 1120
* CHECK dout0_15 vdout0_15ck111 = 0 time = 1120
* CHECK dout0_0 vdout0_0ck114 = 0 time = 1150
* CHECK dout0_1 vdout0_1ck114 = 5.0 time = 1150
* CHECK dout0_2 vdout0_2ck114 = 0 time = 1150
* CHECK dout0_3 vdout0_3ck114 = 5.0 time = 1150
* CHECK dout0_4 vdout0_4ck114 = 0 time = 1150
* CHECK dout0_5 vdout0_5ck114 = 5.0 time = 1150
* CHECK dout0_6 vdout0_6ck114 = 0 time = 1150
* CHECK dout0_7 vdout0_7ck114 = 5.0 time = 1150
* CHECK dout0_8 vdout0_8ck114 = 0 time = 1150
* CHECK dout0_9 vdout0_9ck114 = 0 time = 1150
* CHECK dout0_10 vdout0_10ck114 = 5.0 time = 1150
* CHECK dout0_11 vdout0_11ck114 = 0 time = 1150
* CHECK dout0_12 vdout0_12ck114 = 0 time = 1150
* CHECK dout0_13 vdout0_13ck114 = 5.0 time = 1150
* CHECK dout0_14 vdout0_14ck114 = 5.0 time = 1150
* CHECK dout0_15 vdout0_15ck114 = 0 time = 1150
* CHECK dout0_0 vdout0_0ck117 = 0 time = 1180
* CHECK dout0_1 vdout0_1ck117 = 5.0 time = 1180
* CHECK dout0_2 vdout0_2ck117 = 0 time = 1180
* CHECK dout0_3 vdout0_3ck117 = 0 time = 1180
* CHECK dout0_4 vdout0_4ck117 = 5.0 time = 1180
* CHECK dout0_5 vdout0_5ck117 = 0 time = 1180
* CHECK dout0_6 vdout0_6ck117 = 5.0 time = 1180
* CHECK dout0_7 vdout0_7ck117 = 5.0 time = 1180
* CHECK dout0_8 vdout0_8ck117 = 0 time = 1180
* CHECK dout0_9 vdout0_9ck117 = 0 time = 1180
* CHECK dout0_10 vdout0_10ck117 = 5.0 time = 1180
* CHECK dout0_11 vdout0_11ck117 = 5.0 time = 1180
* CHECK dout0_12 vdout0_12ck117 = 0 time = 1180
* CHECK dout0_13 vdout0_13ck117 = 5.0 time = 1180
* CHECK dout0_14 vdout0_14ck117 = 5.0 time = 1180
* CHECK dout0_15 vdout0_15ck117 = 0 time = 1180
* CHECK dout0_0 vdout0_0ck119 = 5.0 time = 1200
* CHECK dout0_1 vdout0_1ck119 = 0 time = 1200
* CHECK dout0_2 vdout0_2ck119 = 0 time = 1200
* CHECK dout0_3 vdout0_3ck119 = 5.0 time = 1200
* CHECK dout0_4 vdout0_4ck119 = 5.0 time = 1200
* CHECK dout0_5 vdout0_5ck119 = 0 time = 1200
* CHECK dout0_6 vdout0_6ck119 = 0 time = 1200
* CHECK dout0_7 vdout0_7ck119 = 0 time = 1200
* CHECK dout0_8 vdout0_8ck119 = 5.0 time = 1200
* CHECK dout0_9 vdout0_9ck119 = 0 time = 1200
* CHECK dout0_10 vdout0_10ck119 = 0 time = 1200
* CHECK dout0_11 vdout0_11ck119 = 5.0 time = 1200
* CHECK dout0_12 vdout0_12ck119 = 0 time = 1200
* CHECK dout0_13 vdout0_13ck119 = 0 time = 1200
* CHECK dout0_14 vdout0_14ck119 = 5.0 time = 1200
* CHECK dout0_15 vdout0_15ck119 = 0 time = 1200
* CHECK dout0_0 vdout0_0ck123 = 0 time = 1240
* CHECK dout0_1 vdout0_1ck123 = 5.0 time = 1240
* CHECK dout0_2 vdout0_2ck123 = 0 time = 1240
* CHECK dout0_3 vdout0_3ck123 = 0 time = 1240
* CHECK dout0_4 vdout0_4ck123 = 0 time = 1240
* CHECK dout0_5 vdout0_5ck123 = 0 time = 1240
* CHECK dout0_6 vdout0_6ck123 = 0 time = 1240
* CHECK dout0_7 vdout0_7ck123 = 0 time = 1240
* CHECK dout0_8 vdout0_8ck123 = 0 time = 1240
* CHECK dout0_9 vdout0_9ck123 = 0 time = 1240
* CHECK dout0_10 vdout0_10ck123 = 0 time = 1240
* CHECK dout0_11 vdout0_11ck123 = 0 time = 1240
* CHECK dout0_12 vdout0_12ck123 = 0 time = 1240
* CHECK dout0_13 vdout0_13ck123 = 0 time = 1240
* CHECK dout0_14 vdout0_14ck123 = 5.0 time = 1240
* CHECK dout0_15 vdout0_15ck123 = 5.0 time = 1240
* CHECK dout0_0 vdout0_0ck125 = 0 time = 1260
* CHECK dout0_1 vdout0_1ck125 = 5.0 time = 1260
* CHECK dout0_2 vdout0_2ck125 = 0 time = 1260
* CHECK dout0_3 vdout0_3ck125 = 5.0 time = 1260
* CHECK dout0_4 vdout0_4ck125 = 0 time = 1260
* CHECK dout0_5 vdout0_5ck125 = 0 time = 1260
* CHECK dout0_6 vdout0_6ck125 = 0 time = 1260
* CHECK dout0_7 vdout0_7ck125 = 5.0 time = 1260
* CHECK dout0_8 vdout0_8ck125 = 0 time = 1260
* CHECK dout0_9 vdout0_9ck125 = 5.0 time = 1260
* CHECK dout0_10 vdout0_10ck125 = 5.0 time = 1260
* CHECK dout0_11 vdout0_11ck125 = 0 time = 1260
* CHECK dout0_12 vdout0_12ck125 = 0 time = 1260
* CHECK dout0_13 vdout0_13ck125 = 0 time = 1260
* CHECK dout0_14 vdout0_14ck125 = 5.0 time = 1260
* CHECK dout0_15 vdout0_15ck125 = 5.0 time = 1260
* CHECK dout0_0 vdout0_0ck126 = 0 time = 1270
* CHECK dout0_1 vdout0_1ck126 = 5.0 time = 1270
* CHECK dout0_2 vdout0_2ck126 = 0 time = 1270
* CHECK dout0_3 vdout0_3ck126 = 5.0 time = 1270
* CHECK dout0_4 vdout0_4ck126 = 0 time = 1270
* CHECK dout0_5 vdout0_5ck126 = 0 time = 1270
* CHECK dout0_6 vdout0_6ck126 = 0 time = 1270
* CHECK dout0_7 vdout0_7ck126 = 5.0 time = 1270
* CHECK dout0_8 vdout0_8ck126 = 0 time = 1270
* CHECK dout0_9 vdout0_9ck126 = 5.0 time = 1270
* CHECK dout0_10 vdout0_10ck126 = 5.0 time = 1270
* CHECK dout0_11 vdout0_11ck126 = 0 time = 1270
* CHECK dout0_12 vdout0_12ck126 = 0 time = 1270
* CHECK dout0_13 vdout0_13ck126 = 0 time = 1270
* CHECK dout0_14 vdout0_14ck126 = 5.0 time = 1270
* CHECK dout0_15 vdout0_15ck126 = 5.0 time = 1270
* CHECK dout0_0 vdout0_0ck130 = 5.0 time = 1310
* CHECK dout0_1 vdout0_1ck130 = 5.0 time = 1310
* CHECK dout0_2 vdout0_2ck130 = 5.0 time = 1310
* CHECK dout0_3 vdout0_3ck130 = 5.0 time = 1310
* CHECK dout0_4 vdout0_4ck130 = 0 time = 1310
* CHECK dout0_5 vdout0_5ck130 = 0 time = 1310
* CHECK dout0_6 vdout0_6ck130 = 5.0 time = 1310
* CHECK dout0_7 vdout0_7ck130 = 0 time = 1310
* CHECK dout0_8 vdout0_8ck130 = 5.0 time = 1310
* CHECK dout0_9 vdout0_9ck130 = 0 time = 1310
* CHECK dout0_10 vdout0_10ck130 = 5.0 time = 1310
* CHECK dout0_11 vdout0_11ck130 = 0 time = 1310
* CHECK dout0_12 vdout0_12ck130 = 0 time = 1310
* CHECK dout0_13 vdout0_13ck130 = 0 time = 1310
* CHECK dout0_14 vdout0_14ck130 = 5.0 time = 1310
* CHECK dout0_15 vdout0_15ck130 = 0 time = 1310
* CHECK dout0_0 vdout0_0ck131 = 0 time = 1320
* CHECK dout0_1 vdout0_1ck131 = 5.0 time = 1320
* CHECK dout0_2 vdout0_2ck131 = 0 time = 1320
* CHECK dout0_3 vdout0_3ck131 = 5.0 time = 1320
* CHECK dout0_4 vdout0_4ck131 = 0 time = 1320
* CHECK dout0_5 vdout0_5ck131 = 0 time = 1320
* CHECK dout0_6 vdout0_6ck131 = 0 time = 1320
* CHECK dout0_7 vdout0_7ck131 = 5.0 time = 1320
* CHECK dout0_8 vdout0_8ck131 = 0 time = 1320
* CHECK dout0_9 vdout0_9ck131 = 5.0 time = 1320
* CHECK dout0_10 vdout0_10ck131 = 5.0 time = 1320
* CHECK dout0_11 vdout0_11ck131 = 0 time = 1320
* CHECK dout0_12 vdout0_12ck131 = 0 time = 1320
* CHECK dout0_13 vdout0_13ck131 = 0 time = 1320
* CHECK dout0_14 vdout0_14ck131 = 5.0 time = 1320
* CHECK dout0_15 vdout0_15ck131 = 5.0 time = 1320
* CHECK dout0_0 vdout0_0ck133 = 0 time = 1340
* CHECK dout0_1 vdout0_1ck133 = 5.0 time = 1340
* CHECK dout0_2 vdout0_2ck133 = 0 time = 1340
* CHECK dout0_3 vdout0_3ck133 = 5.0 time = 1340
* CHECK dout0_4 vdout0_4ck133 = 0 time = 1340
* CHECK dout0_5 vdout0_5ck133 = 0 time = 1340
* CHECK dout0_6 vdout0_6ck133 = 0 time = 1340
* CHECK dout0_7 vdout0_7ck133 = 5.0 time = 1340
* CHECK dout0_8 vdout0_8ck133 = 0 time = 1340
* CHECK dout0_9 vdout0_9ck133 = 5.0 time = 1340
* CHECK dout0_10 vdout0_10ck133 = 5.0 time = 1340
* CHECK dout0_11 vdout0_11ck133 = 0 time = 1340
* CHECK dout0_12 vdout0_12ck133 = 0 time = 1340
* CHECK dout0_13 vdout0_13ck133 = 0 time = 1340
* CHECK dout0_14 vdout0_14ck133 = 5.0 time = 1340
* CHECK dout0_15 vdout0_15ck133 = 5.0 time = 1340
* CHECK dout0_0 vdout0_0ck135 = 0 time = 1360
* CHECK dout0_1 vdout0_1ck135 = 5.0 time = 1360
* CHECK dout0_2 vdout0_2ck135 = 0 time = 1360
* CHECK dout0_3 vdout0_3ck135 = 0 time = 1360
* CHECK dout0_4 vdout0_4ck135 = 0 time = 1360
* CHECK dout0_5 vdout0_5ck135 = 0 time = 1360
* CHECK dout0_6 vdout0_6ck135 = 0 time = 1360
* CHECK dout0_7 vdout0_7ck135 = 5.0 time = 1360
* CHECK dout0_8 vdout0_8ck135 = 0 time = 1360
* CHECK dout0_9 vdout0_9ck135 = 5.0 time = 1360
* CHECK dout0_10 vdout0_10ck135 = 5.0 time = 1360
* CHECK dout0_11 vdout0_11ck135 = 0 time = 1360
* CHECK dout0_12 vdout0_12ck135 = 0 time = 1360
* CHECK dout0_13 vdout0_13ck135 = 5.0 time = 1360
* CHECK dout0_14 vdout0_14ck135 = 5.0 time = 1360
* CHECK dout0_15 vdout0_15ck135 = 5.0 time = 1360
* CHECK dout0_0 vdout0_0ck138 = 5.0 time = 1390
* CHECK dout0_1 vdout0_1ck138 = 5.0 time = 1390
* CHECK dout0_2 vdout0_2ck138 = 0 time = 1390
* CHECK dout0_3 vdout0_3ck138 = 5.0 time = 1390
* CHECK dout0_4 vdout0_4ck138 = 5.0 time = 1390
* CHECK dout0_5 vdout0_5ck138 = 5.0 time = 1390
* CHECK dout0_6 vdout0_6ck138 = 5.0 time = 1390
* CHECK dout0_7 vdout0_7ck138 = 5.0 time = 1390
* CHECK dout0_8 vdout0_8ck138 = 5.0 time = 1390
* CHECK dout0_9 vdout0_9ck138 = 0 time = 1390
* CHECK dout0_10 vdout0_10ck138 = 0 time = 1390
* CHECK dout0_11 vdout0_11ck138 = 5.0 time = 1390
* CHECK dout0_12 vdout0_12ck138 = 0 time = 1390
* CHECK dout0_13 vdout0_13ck138 = 5.0 time = 1390
* CHECK dout0_14 vdout0_14ck138 = 5.0 time = 1390
* CHECK dout0_15 vdout0_15ck138 = 0 time = 1390
* CHECK dout0_0 vdout0_0ck141 = 5.0 time = 1420
* CHECK dout0_1 vdout0_1ck141 = 0 time = 1420
* CHECK dout0_2 vdout0_2ck141 = 0 time = 1420
* CHECK dout0_3 vdout0_3ck141 = 0 time = 1420
* CHECK dout0_4 vdout0_4ck141 = 5.0 time = 1420
* CHECK dout0_5 vdout0_5ck141 = 0 time = 1420
* CHECK dout0_6 vdout0_6ck141 = 5.0 time = 1420
* CHECK dout0_7 vdout0_7ck141 = 5.0 time = 1420
* CHECK dout0_8 vdout0_8ck141 = 5.0 time = 1420
* CHECK dout0_9 vdout0_9ck141 = 0 time = 1420
* CHECK dout0_10 vdout0_10ck141 = 0 time = 1420
* CHECK dout0_11 vdout0_11ck141 = 5.0 time = 1420
* CHECK dout0_12 vdout0_12ck141 = 5.0 time = 1420
* CHECK dout0_13 vdout0_13ck141 = 5.0 time = 1420
* CHECK dout0_14 vdout0_14ck141 = 0 time = 1420
* CHECK dout0_15 vdout0_15ck141 = 5.0 time = 1420
* CHECK dout0_0 vdout0_0ck143 = 0 time = 1440
* CHECK dout0_1 vdout0_1ck143 = 5.0 time = 1440
* CHECK dout0_2 vdout0_2ck143 = 0 time = 1440
* CHECK dout0_3 vdout0_3ck143 = 0 time = 1440
* CHECK dout0_4 vdout0_4ck143 = 0 time = 1440
* CHECK dout0_5 vdout0_5ck143 = 0 time = 1440
* CHECK dout0_6 vdout0_6ck143 = 0 time = 1440
* CHECK dout0_7 vdout0_7ck143 = 5.0 time = 1440
* CHECK dout0_8 vdout0_8ck143 = 0 time = 1440
* CHECK dout0_9 vdout0_9ck143 = 5.0 time = 1440
* CHECK dout0_10 vdout0_10ck143 = 5.0 time = 1440
* CHECK dout0_11 vdout0_11ck143 = 0 time = 1440
* CHECK dout0_12 vdout0_12ck143 = 0 time = 1440
* CHECK dout0_13 vdout0_13ck143 = 5.0 time = 1440
* CHECK dout0_14 vdout0_14ck143 = 5.0 time = 1440
* CHECK dout0_15 vdout0_15ck143 = 5.0 time = 1440
* CHECK dout0_0 vdout0_0ck144 = 5.0 time = 1450
* CHECK dout0_1 vdout0_1ck144 = 0 time = 1450
* CHECK dout0_2 vdout0_2ck144 = 0 time = 1450
* CHECK dout0_3 vdout0_3ck144 = 0 time = 1450
* CHECK dout0_4 vdout0_4ck144 = 5.0 time = 1450
* CHECK dout0_5 vdout0_5ck144 = 0 time = 1450
* CHECK dout0_6 vdout0_6ck144 = 5.0 time = 1450
* CHECK dout0_7 vdout0_7ck144 = 5.0 time = 1450
* CHECK dout0_8 vdout0_8ck144 = 5.0 time = 1450
* CHECK dout0_9 vdout0_9ck144 = 0 time = 1450
* CHECK dout0_10 vdout0_10ck144 = 0 time = 1450
* CHECK dout0_11 vdout0_11ck144 = 5.0 time = 1450
* CHECK dout0_12 vdout0_12ck144 = 5.0 time = 1450
* CHECK dout0_13 vdout0_13ck144 = 5.0 time = 1450
* CHECK dout0_14 vdout0_14ck144 = 0 time = 1450
* CHECK dout0_15 vdout0_15ck144 = 5.0 time = 1450
* CHECK dout0_0 vdout0_0ck145 = 5.0 time = 1460
* CHECK dout0_1 vdout0_1ck145 = 0 time = 1460
* CHECK dout0_2 vdout0_2ck145 = 0 time = 1460
* CHECK dout0_3 vdout0_3ck145 = 0 time = 1460
* CHECK dout0_4 vdout0_4ck145 = 5.0 time = 1460
* CHECK dout0_5 vdout0_5ck145 = 0 time = 1460
* CHECK dout0_6 vdout0_6ck145 = 5.0 time = 1460
* CHECK dout0_7 vdout0_7ck145 = 5.0 time = 1460
* CHECK dout0_8 vdout0_8ck145 = 5.0 time = 1460
* CHECK dout0_9 vdout0_9ck145 = 0 time = 1460
* CHECK dout0_10 vdout0_10ck145 = 0 time = 1460
* CHECK dout0_11 vdout0_11ck145 = 5.0 time = 1460
* CHECK dout0_12 vdout0_12ck145 = 5.0 time = 1460
* CHECK dout0_13 vdout0_13ck145 = 5.0 time = 1460
* CHECK dout0_14 vdout0_14ck145 = 0 time = 1460
* CHECK dout0_15 vdout0_15ck145 = 5.0 time = 1460
* CHECK dout0_0 vdout0_0ck147 = 0 time = 1480
* CHECK dout0_1 vdout0_1ck147 = 5.0 time = 1480
* CHECK dout0_2 vdout0_2ck147 = 0 time = 1480
* CHECK dout0_3 vdout0_3ck147 = 0 time = 1480
* CHECK dout0_4 vdout0_4ck147 = 0 time = 1480
* CHECK dout0_5 vdout0_5ck147 = 0 time = 1480
* CHECK dout0_6 vdout0_6ck147 = 0 time = 1480
* CHECK dout0_7 vdout0_7ck147 = 5.0 time = 1480
* CHECK dout0_8 vdout0_8ck147 = 0 time = 1480
* CHECK dout0_9 vdout0_9ck147 = 5.0 time = 1480
* CHECK dout0_10 vdout0_10ck147 = 5.0 time = 1480
* CHECK dout0_11 vdout0_11ck147 = 0 time = 1480
* CHECK dout0_12 vdout0_12ck147 = 0 time = 1480
* CHECK dout0_13 vdout0_13ck147 = 5.0 time = 1480
* CHECK dout0_14 vdout0_14ck147 = 5.0 time = 1480
* CHECK dout0_15 vdout0_15ck147 = 5.0 time = 1480
* CHECK dout0_0 vdout0_0ck148 = 5.0 time = 1490
* CHECK dout0_1 vdout0_1ck148 = 0 time = 1490
* CHECK dout0_2 vdout0_2ck148 = 0 time = 1490
* CHECK dout0_3 vdout0_3ck148 = 0 time = 1490
* CHECK dout0_4 vdout0_4ck148 = 5.0 time = 1490
* CHECK dout0_5 vdout0_5ck148 = 0 time = 1490
* CHECK dout0_6 vdout0_6ck148 = 5.0 time = 1490
* CHECK dout0_7 vdout0_7ck148 = 5.0 time = 1490
* CHECK dout0_8 vdout0_8ck148 = 5.0 time = 1490
* CHECK dout0_9 vdout0_9ck148 = 0 time = 1490
* CHECK dout0_10 vdout0_10ck148 = 0 time = 1490
* CHECK dout0_11 vdout0_11ck148 = 5.0 time = 1490
* CHECK dout0_12 vdout0_12ck148 = 5.0 time = 1490
* CHECK dout0_13 vdout0_13ck148 = 5.0 time = 1490
* CHECK dout0_14 vdout0_14ck148 = 0 time = 1490
* CHECK dout0_15 vdout0_15ck148 = 5.0 time = 1490
* CHECK dout0_0 vdout0_0ck150 = 5.0 time = 1510
* CHECK dout0_1 vdout0_1ck150 = 0 time = 1510
* CHECK dout0_2 vdout0_2ck150 = 0 time = 1510
* CHECK dout0_3 vdout0_3ck150 = 0 time = 1510
* CHECK dout0_4 vdout0_4ck150 = 5.0 time = 1510
* CHECK dout0_5 vdout0_5ck150 = 0 time = 1510
* CHECK dout0_6 vdout0_6ck150 = 5.0 time = 1510
* CHECK dout0_7 vdout0_7ck150 = 5.0 time = 1510
* CHECK dout0_8 vdout0_8ck150 = 5.0 time = 1510
* CHECK dout0_9 vdout0_9ck150 = 0 time = 1510
* CHECK dout0_10 vdout0_10ck150 = 0 time = 1510
* CHECK dout0_11 vdout0_11ck150 = 5.0 time = 1510
* CHECK dout0_12 vdout0_12ck150 = 5.0 time = 1510
* CHECK dout0_13 vdout0_13ck150 = 5.0 time = 1510
* CHECK dout0_14 vdout0_14ck150 = 0 time = 1510
* CHECK dout0_15 vdout0_15ck150 = 5.0 time = 1510
* CHECK dout0_0 vdout0_0ck151 = 0 time = 1520
* CHECK dout0_1 vdout0_1ck151 = 5.0 time = 1520
* CHECK dout0_2 vdout0_2ck151 = 0 time = 1520
* CHECK dout0_3 vdout0_3ck151 = 0 time = 1520
* CHECK dout0_4 vdout0_4ck151 = 0 time = 1520
* CHECK dout0_5 vdout0_5ck151 = 0 time = 1520
* CHECK dout0_6 vdout0_6ck151 = 0 time = 1520
* CHECK dout0_7 vdout0_7ck151 = 5.0 time = 1520
* CHECK dout0_8 vdout0_8ck151 = 0 time = 1520
* CHECK dout0_9 vdout0_9ck151 = 5.0 time = 1520
* CHECK dout0_10 vdout0_10ck151 = 5.0 time = 1520
* CHECK dout0_11 vdout0_11ck151 = 0 time = 1520
* CHECK dout0_12 vdout0_12ck151 = 0 time = 1520
* CHECK dout0_13 vdout0_13ck151 = 5.0 time = 1520
* CHECK dout0_14 vdout0_14ck151 = 5.0 time = 1520
* CHECK dout0_15 vdout0_15ck151 = 5.0 time = 1520
* CHECK dout0_0 vdout0_0ck152 = 5.0 time = 1530
* CHECK dout0_1 vdout0_1ck152 = 0 time = 1530
* CHECK dout0_2 vdout0_2ck152 = 0 time = 1530
* CHECK dout0_3 vdout0_3ck152 = 0 time = 1530
* CHECK dout0_4 vdout0_4ck152 = 5.0 time = 1530
* CHECK dout0_5 vdout0_5ck152 = 0 time = 1530
* CHECK dout0_6 vdout0_6ck152 = 5.0 time = 1530
* CHECK dout0_7 vdout0_7ck152 = 5.0 time = 1530
* CHECK dout0_8 vdout0_8ck152 = 5.0 time = 1530
* CHECK dout0_9 vdout0_9ck152 = 0 time = 1530
* CHECK dout0_10 vdout0_10ck152 = 0 time = 1530
* CHECK dout0_11 vdout0_11ck152 = 5.0 time = 1530
* CHECK dout0_12 vdout0_12ck152 = 5.0 time = 1530
* CHECK dout0_13 vdout0_13ck152 = 5.0 time = 1530
* CHECK dout0_14 vdout0_14ck152 = 0 time = 1530
* CHECK dout0_15 vdout0_15ck152 = 5.0 time = 1530
* CHECK dout0_0 vdout0_0ck155 = 5.0 time = 1560
* CHECK dout0_1 vdout0_1ck155 = 0 time = 1560
* CHECK dout0_2 vdout0_2ck155 = 0 time = 1560
* CHECK dout0_3 vdout0_3ck155 = 0 time = 1560
* CHECK dout0_4 vdout0_4ck155 = 5.0 time = 1560
* CHECK dout0_5 vdout0_5ck155 = 0 time = 1560
* CHECK dout0_6 vdout0_6ck155 = 5.0 time = 1560
* CHECK dout0_7 vdout0_7ck155 = 5.0 time = 1560
* CHECK dout0_8 vdout0_8ck155 = 5.0 time = 1560
* CHECK dout0_9 vdout0_9ck155 = 0 time = 1560
* CHECK dout0_10 vdout0_10ck155 = 0 time = 1560
* CHECK dout0_11 vdout0_11ck155 = 5.0 time = 1560
* CHECK dout0_12 vdout0_12ck155 = 5.0 time = 1560
* CHECK dout0_13 vdout0_13ck155 = 5.0 time = 1560
* CHECK dout0_14 vdout0_14ck155 = 0 time = 1560
* CHECK dout0_15 vdout0_15ck155 = 5.0 time = 1560
* CHECK dout0_0 vdout0_0ck156 = 5.0 time = 1570
* CHECK dout0_1 vdout0_1ck156 = 0 time = 1570
* CHECK dout0_2 vdout0_2ck156 = 0 time = 1570
* CHECK dout0_3 vdout0_3ck156 = 0 time = 1570
* CHECK dout0_4 vdout0_4ck156 = 5.0 time = 1570
* CHECK dout0_5 vdout0_5ck156 = 0 time = 1570
* CHECK dout0_6 vdout0_6ck156 = 5.0 time = 1570
* CHECK dout0_7 vdout0_7ck156 = 5.0 time = 1570
* CHECK dout0_8 vdout0_8ck156 = 5.0 time = 1570
* CHECK dout0_9 vdout0_9ck156 = 0 time = 1570
* CHECK dout0_10 vdout0_10ck156 = 0 time = 1570
* CHECK dout0_11 vdout0_11ck156 = 5.0 time = 1570
* CHECK dout0_12 vdout0_12ck156 = 5.0 time = 1570
* CHECK dout0_13 vdout0_13ck156 = 5.0 time = 1570
* CHECK dout0_14 vdout0_14ck156 = 0 time = 1570
* CHECK dout0_15 vdout0_15ck156 = 5.0 time = 1570
* CHECK dout0_0 vdout0_0ck158 = 5.0 time = 1590
* CHECK dout0_1 vdout0_1ck158 = 0 time = 1590
* CHECK dout0_2 vdout0_2ck158 = 0 time = 1590
* CHECK dout0_3 vdout0_3ck158 = 0 time = 1590
* CHECK dout0_4 vdout0_4ck158 = 5.0 time = 1590
* CHECK dout0_5 vdout0_5ck158 = 0 time = 1590
* CHECK dout0_6 vdout0_6ck158 = 5.0 time = 1590
* CHECK dout0_7 vdout0_7ck158 = 5.0 time = 1590
* CHECK dout0_8 vdout0_8ck158 = 5.0 time = 1590
* CHECK dout0_9 vdout0_9ck158 = 0 time = 1590
* CHECK dout0_10 vdout0_10ck158 = 0 time = 1590
* CHECK dout0_11 vdout0_11ck158 = 5.0 time = 1590
* CHECK dout0_12 vdout0_12ck158 = 5.0 time = 1590
* CHECK dout0_13 vdout0_13ck158 = 5.0 time = 1590
* CHECK dout0_14 vdout0_14ck158 = 0 time = 1590
* CHECK dout0_15 vdout0_15ck158 = 5.0 time = 1590
* CHECK dout0_0 vdout0_0ck159 = 0 time = 1600
* CHECK dout0_1 vdout0_1ck159 = 0 time = 1600
* CHECK dout0_2 vdout0_2ck159 = 5.0 time = 1600
* CHECK dout0_3 vdout0_3ck159 = 0 time = 1600
* CHECK dout0_4 vdout0_4ck159 = 0 time = 1600
* CHECK dout0_5 vdout0_5ck159 = 5.0 time = 1600
* CHECK dout0_6 vdout0_6ck159 = 5.0 time = 1600
* CHECK dout0_7 vdout0_7ck159 = 5.0 time = 1600
* CHECK dout0_8 vdout0_8ck159 = 5.0 time = 1600
* CHECK dout0_9 vdout0_9ck159 = 0 time = 1600
* CHECK dout0_10 vdout0_10ck159 = 0 time = 1600
* CHECK dout0_11 vdout0_11ck159 = 0 time = 1600
* CHECK dout0_12 vdout0_12ck159 = 5.0 time = 1600
* CHECK dout0_13 vdout0_13ck159 = 0 time = 1600
* CHECK dout0_14 vdout0_14ck159 = 0 time = 1600
* CHECK dout0_15 vdout0_15ck159 = 5.0 time = 1600
* CHECK dout0_0 vdout0_0ck160 = 5.0 time = 1610
* CHECK dout0_1 vdout0_1ck160 = 0 time = 1610
* CHECK dout0_2 vdout0_2ck160 = 0 time = 1610
* CHECK dout0_3 vdout0_3ck160 = 0 time = 1610
* CHECK dout0_4 vdout0_4ck160 = 5.0 time = 1610
* CHECK dout0_5 vdout0_5ck160 = 0 time = 1610
* CHECK dout0_6 vdout0_6ck160 = 5.0 time = 1610
* CHECK dout0_7 vdout0_7ck160 = 5.0 time = 1610
* CHECK dout0_8 vdout0_8ck160 = 5.0 time = 1610
* CHECK dout0_9 vdout0_9ck160 = 0 time = 1610
* CHECK dout0_10 vdout0_10ck160 = 0 time = 1610
* CHECK dout0_11 vdout0_11ck160 = 5.0 time = 1610
* CHECK dout0_12 vdout0_12ck160 = 5.0 time = 1610
* CHECK dout0_13 vdout0_13ck160 = 5.0 time = 1610
* CHECK dout0_14 vdout0_14ck160 = 0 time = 1610
* CHECK dout0_15 vdout0_15ck160 = 5.0 time = 1610
* CHECK dout0_0 vdout0_0ck163 = 0 time = 1640
* CHECK dout0_1 vdout0_1ck163 = 0 time = 1640
* CHECK dout0_2 vdout0_2ck163 = 5.0 time = 1640
* CHECK dout0_3 vdout0_3ck163 = 0 time = 1640
* CHECK dout0_4 vdout0_4ck163 = 0 time = 1640
* CHECK dout0_5 vdout0_5ck163 = 5.0 time = 1640
* CHECK dout0_6 vdout0_6ck163 = 5.0 time = 1640
* CHECK dout0_7 vdout0_7ck163 = 5.0 time = 1640
* CHECK dout0_8 vdout0_8ck163 = 5.0 time = 1640
* CHECK dout0_9 vdout0_9ck163 = 0 time = 1640
* CHECK dout0_10 vdout0_10ck163 = 0 time = 1640
* CHECK dout0_11 vdout0_11ck163 = 0 time = 1640
* CHECK dout0_12 vdout0_12ck163 = 5.0 time = 1640
* CHECK dout0_13 vdout0_13ck163 = 0 time = 1640
* CHECK dout0_14 vdout0_14ck163 = 0 time = 1640
* CHECK dout0_15 vdout0_15ck163 = 5.0 time = 1640
* CHECK dout0_0 vdout0_0ck164 = 0 time = 1650
* CHECK dout0_1 vdout0_1ck164 = 0 time = 1650
* CHECK dout0_2 vdout0_2ck164 = 5.0 time = 1650
* CHECK dout0_3 vdout0_3ck164 = 0 time = 1650
* CHECK dout0_4 vdout0_4ck164 = 0 time = 1650
* CHECK dout0_5 vdout0_5ck164 = 5.0 time = 1650
* CHECK dout0_6 vdout0_6ck164 = 5.0 time = 1650
* CHECK dout0_7 vdout0_7ck164 = 5.0 time = 1650
* CHECK dout0_8 vdout0_8ck164 = 5.0 time = 1650
* CHECK dout0_9 vdout0_9ck164 = 0 time = 1650
* CHECK dout0_10 vdout0_10ck164 = 0 time = 1650
* CHECK dout0_11 vdout0_11ck164 = 0 time = 1650
* CHECK dout0_12 vdout0_12ck164 = 5.0 time = 1650
* CHECK dout0_13 vdout0_13ck164 = 0 time = 1650
* CHECK dout0_14 vdout0_14ck164 = 0 time = 1650
* CHECK dout0_15 vdout0_15ck164 = 5.0 time = 1650
* CHECK dout0_0 vdout0_0ck168 = 0 time = 1690
* CHECK dout0_1 vdout0_1ck168 = 0 time = 1690
* CHECK dout0_2 vdout0_2ck168 = 5.0 time = 1690
* CHECK dout0_3 vdout0_3ck168 = 5.0 time = 1690
* CHECK dout0_4 vdout0_4ck168 = 5.0 time = 1690
* CHECK dout0_5 vdout0_5ck168 = 5.0 time = 1690
* CHECK dout0_6 vdout0_6ck168 = 5.0 time = 1690
* CHECK dout0_7 vdout0_7ck168 = 0 time = 1690
* CHECK dout0_8 vdout0_8ck168 = 0 time = 1690
* CHECK dout0_9 vdout0_9ck168 = 0 time = 1690
* CHECK dout0_10 vdout0_10ck168 = 5.0 time = 1690
* CHECK dout0_11 vdout0_11ck168 = 0 time = 1690
* CHECK dout0_12 vdout0_12ck168 = 0 time = 1690
* CHECK dout0_13 vdout0_13ck168 = 0 time = 1690
* CHECK dout0_14 vdout0_14ck168 = 0 time = 1690
* CHECK dout0_15 vdout0_15ck168 = 0 time = 1690
* CHECK dout0_0 vdout0_0ck170 = 0 time = 1710
* CHECK dout0_1 vdout0_1ck170 = 0 time = 1710
* CHECK dout0_2 vdout0_2ck170 = 5.0 time = 1710
* CHECK dout0_3 vdout0_3ck170 = 0 time = 1710
* CHECK dout0_4 vdout0_4ck170 = 0 time = 1710
* CHECK dout0_5 vdout0_5ck170 = 5.0 time = 1710
* CHECK dout0_6 vdout0_6ck170 = 5.0 time = 1710
* CHECK dout0_7 vdout0_7ck170 = 5.0 time = 1710
* CHECK dout0_8 vdout0_8ck170 = 5.0 time = 1710
* CHECK dout0_9 vdout0_9ck170 = 0 time = 1710
* CHECK dout0_10 vdout0_10ck170 = 0 time = 1710
* CHECK dout0_11 vdout0_11ck170 = 0 time = 1710
* CHECK dout0_12 vdout0_12ck170 = 5.0 time = 1710
* CHECK dout0_13 vdout0_13ck170 = 0 time = 1710
* CHECK dout0_14 vdout0_14ck170 = 0 time = 1710
* CHECK dout0_15 vdout0_15ck170 = 5.0 time = 1710
* CHECK dout0_0 vdout0_0ck171 = 0 time = 1720
* CHECK dout0_1 vdout0_1ck171 = 0 time = 1720
* CHECK dout0_2 vdout0_2ck171 = 5.0 time = 1720
* CHECK dout0_3 vdout0_3ck171 = 5.0 time = 1720
* CHECK dout0_4 vdout0_4ck171 = 5.0 time = 1720
* CHECK dout0_5 vdout0_5ck171 = 5.0 time = 1720
* CHECK dout0_6 vdout0_6ck171 = 5.0 time = 1720
* CHECK dout0_7 vdout0_7ck171 = 0 time = 1720
* CHECK dout0_8 vdout0_8ck171 = 0 time = 1720
* CHECK dout0_9 vdout0_9ck171 = 0 time = 1720
* CHECK dout0_10 vdout0_10ck171 = 5.0 time = 1720
* CHECK dout0_11 vdout0_11ck171 = 0 time = 1720
* CHECK dout0_12 vdout0_12ck171 = 0 time = 1720
* CHECK dout0_13 vdout0_13ck171 = 0 time = 1720
* CHECK dout0_14 vdout0_14ck171 = 0 time = 1720
* CHECK dout0_15 vdout0_15ck171 = 0 time = 1720
* CHECK dout0_0 vdout0_0ck177 = 0 time = 1780
* CHECK dout0_1 vdout0_1ck177 = 0 time = 1780
* CHECK dout0_2 vdout0_2ck177 = 0 time = 1780
* CHECK dout0_3 vdout0_3ck177 = 5.0 time = 1780
* CHECK dout0_4 vdout0_4ck177 = 5.0 time = 1780
* CHECK dout0_5 vdout0_5ck177 = 5.0 time = 1780
* CHECK dout0_6 vdout0_6ck177 = 0 time = 1780
* CHECK dout0_7 vdout0_7ck177 = 0 time = 1780
* CHECK dout0_8 vdout0_8ck177 = 0 time = 1780
* CHECK dout0_9 vdout0_9ck177 = 5.0 time = 1780
* CHECK dout0_10 vdout0_10ck177 = 5.0 time = 1780
* CHECK dout0_11 vdout0_11ck177 = 0 time = 1780
* CHECK dout0_12 vdout0_12ck177 = 0 time = 1780
* CHECK dout0_13 vdout0_13ck177 = 5.0 time = 1780
* CHECK dout0_14 vdout0_14ck177 = 0 time = 1780
* CHECK dout0_15 vdout0_15ck177 = 5.0 time = 1780
* CHECK dout0_0 vdout0_0ck178 = 0 time = 1790
* CHECK dout0_1 vdout0_1ck178 = 0 time = 1790
* CHECK dout0_2 vdout0_2ck178 = 0 time = 1790
* CHECK dout0_3 vdout0_3ck178 = 5.0 time = 1790
* CHECK dout0_4 vdout0_4ck178 = 5.0 time = 1790
* CHECK dout0_5 vdout0_5ck178 = 5.0 time = 1790
* CHECK dout0_6 vdout0_6ck178 = 0 time = 1790
* CHECK dout0_7 vdout0_7ck178 = 0 time = 1790
* CHECK dout0_8 vdout0_8ck178 = 0 time = 1790
* CHECK dout0_9 vdout0_9ck178 = 5.0 time = 1790
* CHECK dout0_10 vdout0_10ck178 = 5.0 time = 1790
* CHECK dout0_11 vdout0_11ck178 = 0 time = 1790
* CHECK dout0_12 vdout0_12ck178 = 0 time = 1790
* CHECK dout0_13 vdout0_13ck178 = 5.0 time = 1790
* CHECK dout0_14 vdout0_14ck178 = 0 time = 1790
* CHECK dout0_15 vdout0_15ck178 = 5.0 time = 1790
* CHECK dout0_0 vdout0_0ck180 = 0 time = 1810
* CHECK dout0_1 vdout0_1ck180 = 5.0 time = 1810
* CHECK dout0_2 vdout0_2ck180 = 0 time = 1810
* CHECK dout0_3 vdout0_3ck180 = 5.0 time = 1810
* CHECK dout0_4 vdout0_4ck180 = 5.0 time = 1810
* CHECK dout0_5 vdout0_5ck180 = 0 time = 1810
* CHECK dout0_6 vdout0_6ck180 = 5.0 time = 1810
* CHECK dout0_7 vdout0_7ck180 = 5.0 time = 1810
* CHECK dout0_8 vdout0_8ck180 = 0 time = 1810
* CHECK dout0_9 vdout0_9ck180 = 0 time = 1810
* CHECK dout0_10 vdout0_10ck180 = 5.0 time = 1810
* CHECK dout0_11 vdout0_11ck180 = 0 time = 1810
* CHECK dout0_12 vdout0_12ck180 = 0 time = 1810
* CHECK dout0_13 vdout0_13ck180 = 0 time = 1810
* CHECK dout0_14 vdout0_14ck180 = 0 time = 1810
* CHECK dout0_15 vdout0_15ck180 = 5.0 time = 1810
* CHECK dout0_0 vdout0_0ck182 = 5.0 time = 1830
* CHECK dout0_1 vdout0_1ck182 = 5.0 time = 1830
* CHECK dout0_2 vdout0_2ck182 = 5.0 time = 1830
* CHECK dout0_3 vdout0_3ck182 = 5.0 time = 1830
* CHECK dout0_4 vdout0_4ck182 = 5.0 time = 1830
* CHECK dout0_5 vdout0_5ck182 = 0 time = 1830
* CHECK dout0_6 vdout0_6ck182 = 0 time = 1830
* CHECK dout0_7 vdout0_7ck182 = 0 time = 1830
* CHECK dout0_8 vdout0_8ck182 = 0 time = 1830
* CHECK dout0_9 vdout0_9ck182 = 5.0 time = 1830
* CHECK dout0_10 vdout0_10ck182 = 5.0 time = 1830
* CHECK dout0_11 vdout0_11ck182 = 5.0 time = 1830
* CHECK dout0_12 vdout0_12ck182 = 5.0 time = 1830
* CHECK dout0_13 vdout0_13ck182 = 0 time = 1830
* CHECK dout0_14 vdout0_14ck182 = 0 time = 1830
* CHECK dout0_15 vdout0_15ck182 = 5.0 time = 1830
* CHECK dout0_0 vdout0_0ck183 = 5.0 time = 1840
* CHECK dout0_1 vdout0_1ck183 = 5.0 time = 1840
* CHECK dout0_2 vdout0_2ck183 = 5.0 time = 1840
* CHECK dout0_3 vdout0_3ck183 = 5.0 time = 1840
* CHECK dout0_4 vdout0_4ck183 = 5.0 time = 1840
* CHECK dout0_5 vdout0_5ck183 = 0 time = 1840
* CHECK dout0_6 vdout0_6ck183 = 0 time = 1840
* CHECK dout0_7 vdout0_7ck183 = 0 time = 1840
* CHECK dout0_8 vdout0_8ck183 = 0 time = 1840
* CHECK dout0_9 vdout0_9ck183 = 5.0 time = 1840
* CHECK dout0_10 vdout0_10ck183 = 5.0 time = 1840
* CHECK dout0_11 vdout0_11ck183 = 5.0 time = 1840
* CHECK dout0_12 vdout0_12ck183 = 5.0 time = 1840
* CHECK dout0_13 vdout0_13ck183 = 0 time = 1840
* CHECK dout0_14 vdout0_14ck183 = 0 time = 1840
* CHECK dout0_15 vdout0_15ck183 = 5.0 time = 1840
* CHECK dout0_0 vdout0_0ck186 = 5.0 time = 1870
* CHECK dout0_1 vdout0_1ck186 = 0 time = 1870
* CHECK dout0_2 vdout0_2ck186 = 5.0 time = 1870
* CHECK dout0_3 vdout0_3ck186 = 5.0 time = 1870
* CHECK dout0_4 vdout0_4ck186 = 0 time = 1870
* CHECK dout0_5 vdout0_5ck186 = 0 time = 1870
* CHECK dout0_6 vdout0_6ck186 = 5.0 time = 1870
* CHECK dout0_7 vdout0_7ck186 = 5.0 time = 1870
* CHECK dout0_8 vdout0_8ck186 = 5.0 time = 1870
* CHECK dout0_9 vdout0_9ck186 = 5.0 time = 1870
* CHECK dout0_10 vdout0_10ck186 = 5.0 time = 1870
* CHECK dout0_11 vdout0_11ck186 = 5.0 time = 1870
* CHECK dout0_12 vdout0_12ck186 = 5.0 time = 1870
* CHECK dout0_13 vdout0_13ck186 = 0 time = 1870
* CHECK dout0_14 vdout0_14ck186 = 0 time = 1870
* CHECK dout0_15 vdout0_15ck186 = 5.0 time = 1870
* CHECK dout0_0 vdout0_0ck188 = 5.0 time = 1890
* CHECK dout0_1 vdout0_1ck188 = 5.0 time = 1890
* CHECK dout0_2 vdout0_2ck188 = 5.0 time = 1890
* CHECK dout0_3 vdout0_3ck188 = 5.0 time = 1890
* CHECK dout0_4 vdout0_4ck188 = 5.0 time = 1890
* CHECK dout0_5 vdout0_5ck188 = 0 time = 1890
* CHECK dout0_6 vdout0_6ck188 = 0 time = 1890
* CHECK dout0_7 vdout0_7ck188 = 0 time = 1890
* CHECK dout0_8 vdout0_8ck188 = 0 time = 1890
* CHECK dout0_9 vdout0_9ck188 = 5.0 time = 1890
* CHECK dout0_10 vdout0_10ck188 = 5.0 time = 1890
* CHECK dout0_11 vdout0_11ck188 = 5.0 time = 1890
* CHECK dout0_12 vdout0_12ck188 = 5.0 time = 1890
* CHECK dout0_13 vdout0_13ck188 = 0 time = 1890
* CHECK dout0_14 vdout0_14ck188 = 0 time = 1890
* CHECK dout0_15 vdout0_15ck188 = 5.0 time = 1890
* CHECK dout0_0 vdout0_0ck191 = 5.0 time = 1920
* CHECK dout0_1 vdout0_1ck191 = 5.0 time = 1920
* CHECK dout0_2 vdout0_2ck191 = 5.0 time = 1920
* CHECK dout0_3 vdout0_3ck191 = 5.0 time = 1920
* CHECK dout0_4 vdout0_4ck191 = 5.0 time = 1920
* CHECK dout0_5 vdout0_5ck191 = 0 time = 1920
* CHECK dout0_6 vdout0_6ck191 = 0 time = 1920
* CHECK dout0_7 vdout0_7ck191 = 0 time = 1920
* CHECK dout0_8 vdout0_8ck191 = 0 time = 1920
* CHECK dout0_9 vdout0_9ck191 = 5.0 time = 1920
* CHECK dout0_10 vdout0_10ck191 = 5.0 time = 1920
* CHECK dout0_11 vdout0_11ck191 = 5.0 time = 1920
* CHECK dout0_12 vdout0_12ck191 = 5.0 time = 1920
* CHECK dout0_13 vdout0_13ck191 = 0 time = 1920
* CHECK dout0_14 vdout0_14ck191 = 0 time = 1920
* CHECK dout0_15 vdout0_15ck191 = 5.0 time = 1920
* CHECK dout0_0 vdout0_0ck192 = 5.0 time = 1930
* CHECK dout0_1 vdout0_1ck192 = 5.0 time = 1930
* CHECK dout0_2 vdout0_2ck192 = 5.0 time = 1930
* CHECK dout0_3 vdout0_3ck192 = 5.0 time = 1930
* CHECK dout0_4 vdout0_4ck192 = 5.0 time = 1930
* CHECK dout0_5 vdout0_5ck192 = 0 time = 1930
* CHECK dout0_6 vdout0_6ck192 = 0 time = 1930
* CHECK dout0_7 vdout0_7ck192 = 0 time = 1930
* CHECK dout0_8 vdout0_8ck192 = 0 time = 1930
* CHECK dout0_9 vdout0_9ck192 = 5.0 time = 1930
* CHECK dout0_10 vdout0_10ck192 = 5.0 time = 1930
* CHECK dout0_11 vdout0_11ck192 = 5.0 time = 1930
* CHECK dout0_12 vdout0_12ck192 = 5.0 time = 1930
* CHECK dout0_13 vdout0_13ck192 = 0 time = 1930
* CHECK dout0_14 vdout0_14ck192 = 0 time = 1930
* CHECK dout0_15 vdout0_15ck192 = 5.0 time = 1930
* CHECK dout0_0 vdout0_0ck193 = 5.0 time = 1940
* CHECK dout0_1 vdout0_1ck193 = 0 time = 1940
* CHECK dout0_2 vdout0_2ck193 = 5.0 time = 1940
* CHECK dout0_3 vdout0_3ck193 = 5.0 time = 1940
* CHECK dout0_4 vdout0_4ck193 = 0 time = 1940
* CHECK dout0_5 vdout0_5ck193 = 0 time = 1940
* CHECK dout0_6 vdout0_6ck193 = 5.0 time = 1940
* CHECK dout0_7 vdout0_7ck193 = 5.0 time = 1940
* CHECK dout0_8 vdout0_8ck193 = 5.0 time = 1940
* CHECK dout0_9 vdout0_9ck193 = 5.0 time = 1940
* CHECK dout0_10 vdout0_10ck193 = 5.0 time = 1940
* CHECK dout0_11 vdout0_11ck193 = 5.0 time = 1940
* CHECK dout0_12 vdout0_12ck193 = 5.0 time = 1940
* CHECK dout0_13 vdout0_13ck193 = 0 time = 1940
* CHECK dout0_14 vdout0_14ck193 = 0 time = 1940
* CHECK dout0_15 vdout0_15ck193 = 5.0 time = 1940
* CHECK dout0_0 vdout0_0ck194 = 5.0 time = 1950
* CHECK dout0_1 vdout0_1ck194 = 0 time = 1950
* CHECK dout0_2 vdout0_2ck194 = 5.0 time = 1950
* CHECK dout0_3 vdout0_3ck194 = 5.0 time = 1950
* CHECK dout0_4 vdout0_4ck194 = 0 time = 1950
* CHECK dout0_5 vdout0_5ck194 = 0 time = 1950
* CHECK dout0_6 vdout0_6ck194 = 5.0 time = 1950
* CHECK dout0_7 vdout0_7ck194 = 5.0 time = 1950
* CHECK dout0_8 vdout0_8ck194 = 5.0 time = 1950
* CHECK dout0_9 vdout0_9ck194 = 5.0 time = 1950
* CHECK dout0_10 vdout0_10ck194 = 5.0 time = 1950
* CHECK dout0_11 vdout0_11ck194 = 5.0 time = 1950
* CHECK dout0_12 vdout0_12ck194 = 5.0 time = 1950
* CHECK dout0_13 vdout0_13ck194 = 0 time = 1950
* CHECK dout0_14 vdout0_14ck194 = 0 time = 1950
* CHECK dout0_15 vdout0_15ck194 = 5.0 time = 1950
* CHECK dout0_0 vdout0_0ck195 = 5.0 time = 1960
* CHECK dout0_1 vdout0_1ck195 = 5.0 time = 1960
* CHECK dout0_2 vdout0_2ck195 = 5.0 time = 1960
* CHECK dout0_3 vdout0_3ck195 = 5.0 time = 1960
* CHECK dout0_4 vdout0_4ck195 = 5.0 time = 1960
* CHECK dout0_5 vdout0_5ck195 = 0 time = 1960
* CHECK dout0_6 vdout0_6ck195 = 0 time = 1960
* CHECK dout0_7 vdout0_7ck195 = 0 time = 1960
* CHECK dout0_8 vdout0_8ck195 = 0 time = 1960
* CHECK dout0_9 vdout0_9ck195 = 5.0 time = 1960
* CHECK dout0_10 vdout0_10ck195 = 5.0 time = 1960
* CHECK dout0_11 vdout0_11ck195 = 5.0 time = 1960
* CHECK dout0_12 vdout0_12ck195 = 5.0 time = 1960
* CHECK dout0_13 vdout0_13ck195 = 0 time = 1960
* CHECK dout0_14 vdout0_14ck195 = 0 time = 1960
* CHECK dout0_15 vdout0_15ck195 = 5.0 time = 1960
* CHECK dout0_0 vdout0_0ck199 = 5.0 time = 2000
* CHECK dout0_1 vdout0_1ck199 = 5.0 time = 2000
* CHECK dout0_2 vdout0_2ck199 = 5.0 time = 2000
* CHECK dout0_3 vdout0_3ck199 = 5.0 time = 2000
* CHECK dout0_4 vdout0_4ck199 = 5.0 time = 2000
* CHECK dout0_5 vdout0_5ck199 = 0 time = 2000
* CHECK dout0_6 vdout0_6ck199 = 0 time = 2000
* CHECK dout0_7 vdout0_7ck199 = 0 time = 2000
* CHECK dout0_8 vdout0_8ck199 = 0 time = 2000
* CHECK dout0_9 vdout0_9ck199 = 5.0 time = 2000
* CHECK dout0_10 vdout0_10ck199 = 5.0 time = 2000
* CHECK dout0_11 vdout0_11ck199 = 5.0 time = 2000
* CHECK dout0_12 vdout0_12ck199 = 5.0 time = 2000
* CHECK dout0_13 vdout0_13ck199 = 0 time = 2000
* CHECK dout0_14 vdout0_14ck199 = 0 time = 2000
* CHECK dout0_15 vdout0_15ck199 = 5.0 time = 2000
* CHECK dout0_0 vdout0_0ck201 = 5.0 time = 2020
* CHECK dout0_1 vdout0_1ck201 = 5.0 time = 2020
* CHECK dout0_2 vdout0_2ck201 = 5.0 time = 2020
* CHECK dout0_3 vdout0_3ck201 = 5.0 time = 2020
* CHECK dout0_4 vdout0_4ck201 = 5.0 time = 2020
* CHECK dout0_5 vdout0_5ck201 = 0 time = 2020
* CHECK dout0_6 vdout0_6ck201 = 0 time = 2020
* CHECK dout0_7 vdout0_7ck201 = 0 time = 2020
* CHECK dout0_8 vdout0_8ck201 = 0 time = 2020
* CHECK dout0_9 vdout0_9ck201 = 5.0 time = 2020
* CHECK dout0_10 vdout0_10ck201 = 5.0 time = 2020
* CHECK dout0_11 vdout0_11ck201 = 5.0 time = 2020
* CHECK dout0_12 vdout0_12ck201 = 5.0 time = 2020
* CHECK dout0_13 vdout0_13ck201 = 0 time = 2020
* CHECK dout0_14 vdout0_14ck201 = 0 time = 2020
* CHECK dout0_15 vdout0_15ck201 = 5.0 time = 2020
* CHECK dout0_0 vdout0_0ck202 = 5.0 time = 2030
* CHECK dout0_1 vdout0_1ck202 = 0 time = 2030
* CHECK dout0_2 vdout0_2ck202 = 0 time = 2030
* CHECK dout0_3 vdout0_3ck202 = 0 time = 2030
* CHECK dout0_4 vdout0_4ck202 = 5.0 time = 2030
* CHECK dout0_5 vdout0_5ck202 = 0 time = 2030
* CHECK dout0_6 vdout0_6ck202 = 5.0 time = 2030
* CHECK dout0_7 vdout0_7ck202 = 0 time = 2030
* CHECK dout0_8 vdout0_8ck202 = 0 time = 2030
* CHECK dout0_9 vdout0_9ck202 = 0 time = 2030
* CHECK dout0_10 vdout0_10ck202 = 0 time = 2030
* CHECK dout0_11 vdout0_11ck202 = 0 time = 2030
* CHECK dout0_12 vdout0_12ck202 = 5.0 time = 2030
* CHECK dout0_13 vdout0_13ck202 = 5.0 time = 2030
* CHECK dout0_14 vdout0_14ck202 = 5.0 time = 2030
* CHECK dout0_15 vdout0_15ck202 = 0 time = 2030
* CHECK dout0_0 vdout0_0ck204 = 5.0 time = 2050
* CHECK dout0_1 vdout0_1ck204 = 0 time = 2050
* CHECK dout0_2 vdout0_2ck204 = 0 time = 2050
* CHECK dout0_3 vdout0_3ck204 = 0 time = 2050
* CHECK dout0_4 vdout0_4ck204 = 5.0 time = 2050
* CHECK dout0_5 vdout0_5ck204 = 0 time = 2050
* CHECK dout0_6 vdout0_6ck204 = 5.0 time = 2050
* CHECK dout0_7 vdout0_7ck204 = 0 time = 2050
* CHECK dout0_8 vdout0_8ck204 = 0 time = 2050
* CHECK dout0_9 vdout0_9ck204 = 0 time = 2050
* CHECK dout0_10 vdout0_10ck204 = 0 time = 2050
* CHECK dout0_11 vdout0_11ck204 = 0 time = 2050
* CHECK dout0_12 vdout0_12ck204 = 5.0 time = 2050
* CHECK dout0_13 vdout0_13ck204 = 5.0 time = 2050
* CHECK dout0_14 vdout0_14ck204 = 5.0 time = 2050
* CHECK dout0_15 vdout0_15ck204 = 0 time = 2050
.include /home/claude/gli/openram_out/sram_16x16/functional_meas.sp
* probe is used for hspice/xa, while plot is used in ngspice
*.probe V(*)
*.plot V(*)
.end
